* por_comparator -- generated by design/netlist.py from design/por_comparator.sch
* Do not edit: edit the schematic and re-run the export.
** sch_path: design/por_comparator.sch
.subckt por_comparator VDD VSS IBIAS VREF BIAS_OK POR_RAW
*.PININFO VDD:B VSS:B IBIAS:I VREF:I BIAS_OK:I POR_RAW:O
Rplaceholder_por_raw POR_RAW VSS 1T m=1
**** begin user architecture code

* PLACEHOLDER: por_comparator has no internals yet -- they land with issue #10.
* The Rplaceholder_* devices in this cell are 1 Tohm terminations, not
* design content: they exist only so this stub is ERC-clean and DC-solvable.
* Nothing in this cell may be cited as simulation evidence.

**** end user architecture code
.ends
