* tb_por_threshold_mc -- GENERATED by sim/build_tb.py
* Do not edit. Sources:
*   sim/por-threshold-mc/testbench/stimulus.spice
*   design/netlist/por_comparator.spice  (sha256 0d1814a878b2cf7d5dc567ff2eac6c54096c5fc873f3c8540a75dc0a65810bbe)
* Regenerate with:
*   python3 sim/build_tb.py

* por-threshold-mc -- stimulus half of the testbench fragment.
*
* The other half is a verbatim copy of design/netlist/por_comparator.spice,
* appended by sim/build_tb.py to produce tb_por_threshold_mc.spice. Edit
* THIS file (or the schematic), never the generated fragment.
*
* Netlist FRAGMENT: no .include / .lib / .temp / .control / .end -- the
* harness owns those. Parameters supplied by sim/harness/montecarlo.py:
* vdd_val, vdd_nom, temp_c (plus .option seed=/.param sw_stat_mismatch=1).
*
* WHAT THIS EXPERIMENT SUBSTANTIATES (issue #15)
*
* spec/target-spec.md#por-vth-rise, #por-vth-fall, #por-hysteresis -- the
* LOCAL MISMATCH share (comparator input-pair offset, divider-ratio
* mismatch) of all three [3sigma] rows, at each row's own named binding
* corner (see the per-row "binds at" text in spec/target-spec.md section 4.1
* and sim/por-vth/'s measured record, which is where these five distinct
* (process, temperature, rail) binding points come from). Complements the
* deterministic corner-sweep systematic/corner share sim/por-vth/ (#14)
* already published on the full assembly.
*
* IDEALISED IBIAS/VREF, SAME CELL sim/por-comparator-designer-check/ uses --
* deliberate, not a cut corner, for the identical reason
* sim/temp-accuracy-mc/'s stimulus documents: the comparator's own offset and
* the divider's own ratio mismatch are properties of THIS cell's devices,
* not of bias_core's startup dynamics, so isolating them on the cheaper
* idealised-bias cell-level testbench is the right level to run N=500 per
* binding point x 5 binding points = 2500 ngspice invocations at. The
* assembled-path corner sweep (#14, sim/por-vth/) remains the authority for
* the process/temperature/rail axis; this experiment adds the local-mismatch
* axis on top, at #14's own measured binding points.
*
* ONE INSTANCE, ONE TRIANGLE WAVE -- load-bearing, not a simplification.
* sim/por-comparator-designer-check/ uses TWO instances (xup/xdn) for its
* rise/fall pair because with mismatch off (sw_stat_mismatch=0 there) the two
* instances are electrically identical, so "same corner point" is exact
* either way. Here mismatch is ON: two separate instances would draw TWO
* INDEPENDENT random mismatch realisations, so a "hysteresis" computed as
* their difference would be measuring cross-die spread dressed up as a
* same-die quantity -- exactly backwards from spec/target-spec.md's own
* framing ("Both edges measured at the same corner point (hysteresis is a
* same-die difference, not a corner-to-corner one)"). One instance, ramped
* up then down, guarantees both edges see the identical mismatch draw by
* construction.
*
* RAMP RATE: fast. Unlike sim/por-vth/'s full-assembly deck, IBIAS and VREF
* here are idealised DC sources with no startup/settling dynamics to wait
* out (matching sim/por-comparator-designer-check/'s own choice of a 10 ms
* single-edge ramp) -- there is no bias_core-starved-loop lag this comparator
* has to be given time to settle out of. 0 -> vdd_val in 5 ms, held to
* 10 ms, vdd_val -> 0 by 15 ms: comfortably inside the ratified
* por-ramp-rate envelope and enough for BIAS_OK-tied-high measurement of
* both crossings in one transient, at roughly 1 second of ngspice time per
* sample (see sim/harness montecarlo.py's module docstring for the budget
* this was sized against).
*
* BIAS_OK tied high throughout (including the 0 V endpoints), exactly as
* sim/por-comparator-designer-check/ does: this is the comparator's OWN
* threshold characteristic over its full input range, not a statement about
* when BIAS_OK is realistically valid (that ordering is #11/#14's job).

vsup vdd 0 pwl(0 0 5m {vdd_val} 10m {vdd_val} 15m 0)
vok bias_ok 0 dc {vdd_val}
vref vref 0 dc 1.2
ibref vdd ibias dc 500n
xdut vdd 0 ibias vref bias_ok por_raw por_comparator

* por_comparator -- generated by design/netlist.py from design/por_comparator.sch
* Do not edit: edit the schematic and re-run the export.
** sch_path: design/por_comparator.sch
.subckt por_comparator VDD VSS IBIAS VREF BIAS_OK POR_RAW
*.PININFO VDD:B VSS:B IBIAS:I VREF:I BIAS_OK:I POR_RAW:O
XMENP BIAS_OKB BIAS_OK VDD VDD pfet_03v3 L=0.5u W=2u nf=1 ad='int((nf+1)/2) * W/nf * 0.18u' as='int((nf+2)/2) * W/nf * 0.18u' pd='2*int((nf+1)/2) * (W/nf + 0.18u)'
+ ps='2*int((nf+2)/2) * (W/nf + 0.18u)' nrd='0.18u / W' nrs='0.18u / W' sa=0 sb=0 sd=0 m=1
XMENN BIAS_OKB BIAS_OK VSS VSS nfet_03v3 L=0.5u W=1u nf=1 ad='int((nf+1)/2) * W/nf * 0.18u' as='int((nf+2)/2) * W/nf * 0.18u' pd='2*int((nf+1)/2) * (W/nf + 0.18u)'
+ ps='2*int((nf+2)/2) * (W/nf + 0.18u)' nrd='0.18u / W' nrs='0.18u / W' sa=0 sb=0 sd=0 m=1
XMBD IBIAS NBG VSS VSS nfet_03v3 L=2u W=2u nf=1 ad='int((nf+1)/2) * W/nf * 0.18u' as='int((nf+2)/2) * W/nf * 0.18u' pd='2*int((nf+1)/2) * (W/nf + 0.18u)'
+ ps='2*int((nf+2)/2) * (W/nf + 0.18u)' nrd='0.18u / W' nrs='0.18u / W' sa=0 sb=0 sd=0 m=1
XMPASS IBIAS BIAS_OK NBG VSS nfet_03v3 L=0.5u W=2u nf=1 ad='int((nf+1)/2) * W/nf * 0.18u' as='int((nf+2)/2) * W/nf * 0.18u' pd='2*int((nf+1)/2) * (W/nf + 0.18u)'
+ ps='2*int((nf+2)/2) * (W/nf + 0.18u)' nrd='0.18u / W' nrs='0.18u / W' sa=0 sb=0 sd=0 m=1
XMDNB NBG BIAS_OKB VSS VSS nfet_03v3 L=0.5u W=2u nf=1 ad='int((nf+1)/2) * W/nf * 0.18u' as='int((nf+2)/2) * W/nf * 0.18u' pd='2*int((nf+1)/2) * (W/nf + 0.18u)'
+ ps='2*int((nf+2)/2) * (W/nf + 0.18u)' nrd='0.18u / W' nrs='0.18u / W' sa=0 sb=0 sd=0 m=1
XMDIB IBIAS BIAS_OKB VSS VSS nfet_03v3 L=1u W=1u nf=1 ad='int((nf+1)/2) * W/nf * 0.18u' as='int((nf+2)/2) * W/nf * 0.18u' pd='2*int((nf+1)/2) * (W/nf + 0.18u)'
+ ps='2*int((nf+2)/2) * (W/nf + 0.18u)' nrd='0.18u / W' nrs='0.18u / W' sa=0 sb=0 sd=0 m=1
XRTOP SNS VDD VSS ppolyf_u_3k r_width=2u r_length=7897.44u m=1
XRBOT SNSB SNS VSS ppolyf_u_3k r_width=2u r_length=6769.23u m=1
XRHYS VSS SNSB VSS ppolyf_u_3k r_width=2u r_length=775.0u m=1
XMHSW SNSB N1 VSS VSS nfet_03v3 L=0.5u W=10u nf=1 ad='int((nf+1)/2) * W/nf * 0.18u' as='int((nf+2)/2) * W/nf * 0.18u' pd='2*int((nf+1)/2) * (W/nf + 0.18u)'
+ ps='2*int((nf+2)/2) * (W/nf + 0.18u)' nrd='0.18u / W' nrs='0.18u / W' sa=0 sb=0 sd=0 m=1
XMTAIL TN NBG VSS VSS nfet_03v3 L=10u W=1u nf=1 ad='int((nf+1)/2) * W/nf * 0.18u' as='int((nf+2)/2) * W/nf * 0.18u' pd='2*int((nf+1)/2) * (W/nf + 0.18u)'
+ ps='2*int((nf+2)/2) * (W/nf + 0.18u)' nrd='0.18u / W' nrs='0.18u / W' sa=0 sb=0 sd=0 m=1
XMINA NA SNS TN VSS nfet_03v3 L=1u W=2u nf=1 ad='int((nf+1)/2) * W/nf * 0.18u' as='int((nf+2)/2) * W/nf * 0.18u' pd='2*int((nf+1)/2) * (W/nf + 0.18u)'
+ ps='2*int((nf+2)/2) * (W/nf + 0.18u)' nrd='0.18u / W' nrs='0.18u / W' sa=0 sb=0 sd=0 m=1
XMINB CMPO VREF TN VSS nfet_03v3 L=1u W=2u nf=1 ad='int((nf+1)/2) * W/nf * 0.18u' as='int((nf+2)/2) * W/nf * 0.18u' pd='2*int((nf+1)/2) * (W/nf + 0.18u)'
+ ps='2*int((nf+2)/2) * (W/nf + 0.18u)' nrd='0.18u / W' nrs='0.18u / W' sa=0 sb=0 sd=0 m=1
XMLA NA NA VDDA VDD pfet_03v3 L=1u W=4u nf=1 ad='int((nf+1)/2) * W/nf * 0.18u' as='int((nf+2)/2) * W/nf * 0.18u' pd='2*int((nf+1)/2) * (W/nf + 0.18u)'
+ ps='2*int((nf+2)/2) * (W/nf + 0.18u)' nrd='0.18u / W' nrs='0.18u / W' sa=0 sb=0 sd=0 m=1
XMLB CMPO NA VDDA VDD pfet_03v3 L=1u W=4u nf=1 ad='int((nf+1)/2) * W/nf * 0.18u' as='int((nf+2)/2) * W/nf * 0.18u' pd='2*int((nf+1)/2) * (W/nf + 0.18u)'
+ ps='2*int((nf+2)/2) * (W/nf + 0.18u)' nrd='0.18u / W' nrs='0.18u / W' sa=0 sb=0 sd=0 m=1
XMENSRC VDDA BIAS_OKB VDD VDD pfet_03v3 L=0.5u W=4u nf=1 ad='int((nf+1)/2) * W/nf * 0.18u' as='int((nf+2)/2) * W/nf * 0.18u' pd='2*int((nf+1)/2) * (W/nf + 0.18u)'
+ ps='2*int((nf+2)/2) * (W/nf + 0.18u)' nrd='0.18u / W' nrs='0.18u / W' sa=0 sb=0 sd=0 m=1
XMDCMPO CMPO BIAS_OKB VSS VSS nfet_03v3 L=1u W=2u nf=1 ad='int((nf+1)/2) * W/nf * 0.18u' as='int((nf+2)/2) * W/nf * 0.18u' pd='2*int((nf+1)/2) * (W/nf + 0.18u)'
+ ps='2*int((nf+2)/2) * (W/nf + 0.18u)' nrd='0.18u / W' nrs='0.18u / W' sa=0 sb=0 sd=0 m=1
XMI1P N1 CMPO VDD VDD pfet_03v3 L=0.5u W=2u nf=1 ad='int((nf+1)/2) * W/nf * 0.18u' as='int((nf+2)/2) * W/nf * 0.18u' pd='2*int((nf+1)/2) * (W/nf + 0.18u)'
+ ps='2*int((nf+2)/2) * (W/nf + 0.18u)' nrd='0.18u / W' nrs='0.18u / W' sa=0 sb=0 sd=0 m=1
XMI1N N1 CMPO VSS VSS nfet_03v3 L=0.5u W=1u nf=1 ad='int((nf+1)/2) * W/nf * 0.18u' as='int((nf+2)/2) * W/nf * 0.18u' pd='2*int((nf+1)/2) * (W/nf + 0.18u)'
+ ps='2*int((nf+2)/2) * (W/nf + 0.18u)' nrd='0.18u / W' nrs='0.18u / W' sa=0 sb=0 sd=0 m=1
XMI2P POR_RAW N1 VDD VDD pfet_03v3 L=0.5u W=2u nf=1 ad='int((nf+1)/2) * W/nf * 0.18u' as='int((nf+2)/2) * W/nf * 0.18u' pd='2*int((nf+1)/2) * (W/nf + 0.18u)'
+ ps='2*int((nf+2)/2) * (W/nf + 0.18u)' nrd='0.18u / W' nrs='0.18u / W' sa=0 sb=0 sd=0 m=1
XMI2N POR_RAW N1 VSS VSS nfet_03v3 L=0.5u W=1u nf=1 ad='int((nf+1)/2) * W/nf * 0.18u' as='int((nf+2)/2) * W/nf * 0.18u' pd='2*int((nf+1)/2) * (W/nf + 0.18u)'
+ ps='2*int((nf+2)/2) * (W/nf + 0.18u)' nrd='0.18u / W' nrs='0.18u / W' sa=0 sb=0 sd=0 m=1
.ends
