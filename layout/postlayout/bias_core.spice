* bias_core -- post-layout netlist
* GENERATED by layout/postlayout.py -- do not edit.
*
* FROM THE LAYOUT: every device and its dimensions, the whole
*   topology, and first-order interconnect R/C on 47/47 nets
*   (sigma 1961.6 fF, of which 0.585 fF is net-to-net coupling).
*   One star per net: <net> is the hub, <net>__t<k> each device
*   terminal on it, R<net>_t<k> the arm between them.
*   klt 0.6.0, deck gf180mcu,
*   GDS sha256 d7380cd0dcf59989...
* Net names are the schematic's, restored through klt lvs's own net
*   correspondence -- match, 47/47 nets, every one paired.
*
* NOT FROM THE LAYOUT -- see layout/postlayout/AUDIT.md:
*   3 body/plate net(s) tied to the net the schematic puts
*   them on. The extraction deck's connectivity stack does not reach
*   an Nwell, a substrate ring, a bipolar base well or a MiM plate,
*   so they extract isolated and would otherwise float.
*   No ideal device: every golden device is drawn.
*
.subckt bias_core VDD VSS IBIAS VREF BIAS_OK

* --- drawn devices ---
X1 VDD__t11 VDD__t10 KS1__t2 VSS__t57 nfet_03v3 L=8u W=1u nf=1 ad=0.8p as=0.8p pd=3.6u ps=3.6u m=1
X2 KS1__t1 KS1__t0 KS2__t2 VSS__t58 nfet_03v3 L=8u W=1u nf=1 ad=0.8p as=0.8p pd=3.6u ps=3.6u m=1
X3 KS2__t1 KS2__t0 KS3__t2 VSS__t59 nfet_03v3 L=8u W=1u nf=1 ad=0.8p as=0.8p pd=3.6u ps=3.6u m=1
X4 KS3__t1 KS3__t0 KS4__t0 VSS__t60 nfet_03v3 L=8u W=1u nf=1 ad=0.8p as=0.8p pd=3.6u ps=3.6u m=1
X5 KS4__t1 KS4__t2 NKG__t3 VSS__t61 nfet_03v3 L=8u W=1u nf=1 ad=0.8p as=0.8p pd=3.6u ps=3.6u m=1
X6 PG__t3 NKG__t1 VSS__t4 VSS__t62 nfet_03v3 L=4u W=1u nf=1 ad=0.8p as=0.8p pd=3.6u ps=3.6u m=1
X7 NBG__t3 NBG__t1 VSS__t0 VSS__t63 nfet_03v3 L=4u W=2u nf=1 ad=1.6p as=1.6p pd=5.6u ps=5.6u m=1
X8 PB__t2 NBG__t2 VSS__t18 VSS__t64 nfet_03v3 L=4u W=2u nf=1 ad=1.6p as=1.6p pd=5.6u ps=5.6u m=1
X9 NKM__t3 NKM__t2 VSS__t19 VSS__t65 nfet_03v3 L=4u W=2u nf=1 ad=1.6p as=1.6p pd=5.6u ps=5.6u m=1
X10 NOKL__t2 NOKL__t0 VSS__t20 VSS__t66 nfet_03v3 L=4u W=2u nf=1 ad=1.6p as=1.6p pd=5.6u ps=5.6u m=1
X11 NOKO__t2 NOKL__t1 VSS__t22 VSS__t67 nfet_03v3 L=4u W=2u nf=1 ad=1.6p as=1.6p pd=5.6u ps=5.6u m=1
X12 NOKO__t0 NKG__t2 VSS__t5 VSS__t69 nfet_03v3 L=1u W=2u nf=1 ad=1.6p as=1.6p pd=5.6u ps=5.6u m=1
X13 NOKX__t2 NOKO__t1 VSS__t21 VSS__t68 nfet_03v3 L=4u W=2u nf=1 ad=1.6p as=1.6p pd=5.6u ps=5.6u m=1
X14 N1__t1 N1__t2 VSS__t1 VSS__t70 nfet_03v3 L=8u W=4u nf=1 ad=3.2p as=3.2p pd=9.6u ps=9.6u m=1
X15 N2__t2 N1__t3 VSS__t17 VSS__t71 nfet_03v3 L=8u W=4u nf=1 ad=3.2p as=3.2p pd=9.6u ps=9.6u m=1
X16 BIAS_OK__t0 NOKX__t0 VSS__t6 VSS__t72 nfet_03v3 L=0.5u W=4u nf=1 ad=3.2p as=3.2p pd=9.6u ps=9.6u m=1
X17 PG__t2 N2__t0 VSS__t2 VSS__t73 nfet_03v3 L=8u W=8u nf=1 ad=6.4p as=6.4p pd=17.6u ps=17.6u m=1
X18 NKG__t0 NKM__t1 VSS__t3 VSS__t74 nfet_03v3 L=4u W=8u nf=1 ad=6.4p as=6.4p pd=17.6u ps=17.6u m=1
X19 NKM__t0 PB__t1 VDD__t7 VDD__t8 pfet_03v3 L=4u W=1u nf=1 ad=0.8p as=0.8p pd=3.6u ps=3.6u m=1
X20 TOK__t0 PB__t4 VDD__t17 VDD__t14 pfet_03v3 L=4u W=1u nf=1 ad=0.8p as=0.8p pd=3.6u ps=3.6u m=1
X21 NOKX__t3 PB__t3 VDD__t15 VDD__t12 pfet_03v3 L=4u W=1u nf=1 ad=0.8p as=0.8p pd=3.6u ps=3.6u m=1
X22 BIAS_OK__t1 NOKX__t4 VDD__t16 VDD__t13 pfet_03v3 L=4u W=1u nf=1 ad=0.8p as=0.8p pd=3.6u ps=3.6u m=1
X23 NBG__t0 PG__t1 VDD__t2 VDD__t3 pfet_03v3 L=4u W=2u nf=1 ad=1.6p as=1.6p pd=5.6u ps=5.6u m=1
X24 PB__t5 PB__t8 VDD__t24 VDD__t21 pfet_03v3 L=4u W=2u nf=1 ad=1.6p as=1.6p pd=5.6u ps=5.6u m=1
X25 NT__t2 PB__t7 VDD__t23 VDD__t20 pfet_03v3 L=4u W=2u nf=1 ad=1.6p as=1.6p pd=5.6u ps=5.6u m=1
X26 PG__t5 PB__t6 VDD__t22 VDD__t19 pfet_03v3 L=4u W=2u nf=1 ad=1.6p as=1.6p pd=5.6u ps=5.6u m=1
X27 NA__t0 PG__t0 VDD__t0 VDD__t1 pfet_03v3 L=4u W=8u nf=1 ad=6.4p as=6.4p pd=17.6u ps=17.6u m=1
X28 NBTOP__t1 PG__t7 VDD__t30 VDD__t28 pfet_03v3 L=4u W=8u nf=1 ad=6.4p as=6.4p pd=17.6u ps=17.6u m=1
X29 VREF__t1 PG__t6 VDD__t29 VDD__t27 pfet_03v3 L=4u W=8u nf=1 ad=6.4p as=6.4p pd=17.6u ps=17.6u m=1
X30 NOKO__t3 NA__t3 TOK__t2 VDD__t26 pfet_03v3 L=4u W=8u nf=1 ad=6.4p as=6.4p pd=17.6u ps=17.6u m=1
X31 NOKL__t3 NBTOP__t2 TOK__t1 VDD__t25 pfet_03v3 L=4u W=8u nf=1 ad=6.4p as=6.4p pd=17.6u ps=17.6u m=1
X32 N1__t0 NA__t1 NT__t0 VDD__t6 pfet_03v3 L=4u W=16u nf=1 ad=12.8p as=12.8p pd=33.6u ps=33.6u m=1
X33 N2__t3 NB__t2 NT__t1 VDD__t18 pfet_03v3 L=4u W=16u nf=1 ad=12.8p as=12.8p pd=33.6u ps=33.6u m=1
X34 IBIAS__t0 PB__t0 VDD__t4 VDD__t5 pfet_03v3 L=4u W=40u nf=1 ad=32p as=32p pd=81.6u ps=81.6u m=1
X35 VSS__t23 VSS__t9 EC__t2 pnp_10p00x10p00
X36 VSS__t24 VSS__t13 EC__t5 pnp_10p00x10p00
X37 VSS__t25 VSS__t10 EC__t3 pnp_10p00x10p00
X38 VSS__t26 VSS__t11 EC__t4 pnp_10p00x10p00
X39 VSS__t27 VSS__t12 NA__t2 pnp_10p00x10p00
X40 VSS__t28 VSS__t8 EC__t1 pnp_10p00x10p00
X41 VSS__t29 VSS__t16 ER__t1 pnp_10p00x10p00
X42 VSS__t30 VSS__t7 EC__t8 pnp_10p00x10p00
X43 VSS__t31 VSS__t15 EC__t7 pnp_10p00x10p00
X44 VSS__t32 VSS__t14 EC__t6 pnp_10p00x10p00
X45 VDD__t9 NOKX__t1 cap_mim_2f0_m3m4_noshield c_width=6u c_length=6u
X46 PG__t4 NZ__t0 cap_mim_2f0_m3m4_noshield c_width=20u c_length=20u
X47 VREF__t0 XR2__1__t0 VSS__t33 ppolyf_u_3k r_width=2u r_length=256.5u
X48 XR2__2__t0 XR2__1__t1 VSS__t34 ppolyf_u_3k r_width=2u r_length=256.5u
X49 XR2__2__t1 XR2__3__t1 VSS__t41 ppolyf_u_3k r_width=2u r_length=256.5u
X50 XR2__4__t1 XR2__3__t0 VSS__t35 ppolyf_u_3k r_width=2u r_length=256.5u
X51 XR2__4__t0 XR2__5__t0 VSS__t42 ppolyf_u_3k r_width=2u r_length=256.5u
X52 XR2__6__t1 XR2__5__t1 VSS__t36 ppolyf_u_3k r_width=2u r_length=256.5u
X53 XR2__6__t0 XR2__7__t0 VSS__t43 ppolyf_u_3k r_width=2u r_length=256.5u
X54 XR2__8__t1 XR2__7__t1 VSS__t37 ppolyf_u_3k r_width=2u r_length=256.5u
X55 XR2__8__t0 XR2__9__t0 VSS__t44 ppolyf_u_3k r_width=2u r_length=256.5u
X56 XR2__10__t1 XR2__9__t1 VSS__t38 ppolyf_u_3k r_width=2u r_length=256.5u
X57 XR2__10__t0 XR2__11__t0 VSS__t45 ppolyf_u_3k r_width=2u r_length=256.5u
X58 XR2__12__t1 XR2__11__t1 VSS__t39 ppolyf_u_3k r_width=2u r_length=256.5u
X59 XR2__12__t0 XR2__13__t0 VSS__t46 ppolyf_u_3k r_width=2u r_length=256.5u
X60 XR2__14__t1 XR2__13__t1 VSS__t40 ppolyf_u_3k r_width=2u r_length=256.5u
X61 XR2__14__t0 XR2__15__t0 VSS__t47 ppolyf_u_3k r_width=2u r_length=256.5u
X62 ER__t0 XR2__15__t1 VSS__t48 ppolyf_u_3k r_width=2u r_length=256.5u
X63 NZ__t1 XRZ__1__t0 VSS__t49 ppolyf_u_3k r_width=2u r_length=254u
X64 XRZ__2__t0 XRZ__1__t1 VSS__t50 ppolyf_u_3k r_width=2u r_length=254u
X65 XRZ__2__t1 XRZ__3__t0 VSS__t51 ppolyf_u_3k r_width=2u r_length=254u
X66 N2__t1 XRZ__3__t1 VSS__t52 ppolyf_u_3k r_width=2u r_length=254u
X67 NB__t0 XR1__1__t0 VSS__t53 ppolyf_u_3k r_width=2u r_length=175u
X68 EC__t0 XR1__1__t1 VSS__t54 ppolyf_u_3k r_width=2u r_length=175u
X69 NBTOP__t0 XRT__1__t0 VSS__t55 ppolyf_u_3k r_width=2u r_length=8.75u
X70 NB__t1 XRT__1__t1 VSS__t56 ppolyf_u_3k r_width=2u r_length=8.75u

R_10_t0 NT__t0 NT 627.59414468
R_10_t1 NT__t1 NT 1882.86781906
R_10_t2 NT__t2 NT 2174.12383626
C_10 NT VSS 4.9951788e-14
R_11_t0 N1__t0 N1 2483.75464397
R_11_t1 N1__t1 N1 686.286100229
R_11_t2 N1__t2 N1 686.286100229
R_11_t3 N1__t3 N1 1111.53145557
C_11 N1 VSS 5.978126e-14
R_12_t0 N2__t0 N2 827.153205074
R_12_t1 N2__t1 N2 3874.61260019
R_12_t2 N2__t2 N2 979.748226084
R_12_t3 N2__t3 N2 2173.53656866
C_12 N2 VSS 8.4773094e-14
R_13_t0 NKM__t0 NKM 2437.59006439
R_13_t1 NKM__t1 NKM 913.50607551
R_13_t2 NKM__t2 NKM 762.895630051
R_13_t3 NKM__t3 NKM 762.895630051
C_13 NKM VSS 5.7923066e-14
R_14_t0 TOK__t0 TOK 2208.25155211
R_14_t1 TOK__t1 TOK 2114.24861265
R_14_t2 TOK__t2 TOK 368.025235243
C_14 TOK VSS 5.2350545e-14
R_15_t0 NOKO__t0 NOKO 798.735608557
R_15_t1 NOKO__t1 NOKO 900.604258303
R_15_t2 NOKO__t2 NOKO 696.871607469
R_15_t3 NOKO__t3 NOKO 2396.20682567
C_15 NOKO VSS 5.9161863e-14
R_16_t0 NOKL__t0 NOKL 764.207687226
R_16_t1 NOKL__t1 NOKL 913.585012659
R_16_t2 NOKL__t2 NOKL 764.207687226
R_16_t3 NOKL__t3 NOKL 2441.99661289
C_16 NOKL VSS 6.0794305e-14
R_17_t0 NOKX__t0 NOKX 648.721578834
R_17_t1 NOKX__t1 NOKX 1279.90073207
R_17_t2 NOKX__t2 NOKX 597.005875788
R_17_t3 NOKX__t3 NOKX 1204.49559346
R_17_t4 NOKX__t4 NOKX 1128.46241984
C_17 NOKX VSS 6.414389e-14
R_18_t0 KS1__t0 KS1 1204.712775
R_18_t1 KS1__t1 KS1 1204.712775
R_18_t2 KS1__t2 KS1 2409.42555
C_18 KS1 VSS 5.4330567e-14
R_19_t0 KS2__t0 KS2 1204.847775
R_19_t1 KS2__t1 KS2 1204.847775
R_19_t2 KS2__t2 KS2 2409.69555
C_19 KS2 VSS 5.4548635e-14
R_20_t0 KS3__t0 KS3 1204.98275
R_20_t1 KS3__t1 KS3 1204.98275
R_20_t2 KS3__t2 KS3 2409.9655
C_20 KS3 VSS 5.4766704e-14
R_21_t0 KS4__t0 KS4 2410.2355
R_21_t1 KS4__t1 KS4 1205.11775
R_21_t2 KS4__t2 KS4 1205.11775
C_21 KS4 VSS 5.4984773e-14
R_22_t0 NKG__t0 NKG 486.627728791
R_22_t1 NKG__t1 NKG 276.439255717
R_22_t2 NKG__t2 NKG 2120.36414661
R_22_t3 NKG__t3 NKG 1964.61916888
C_22 NKG VSS 5.7785044e-14
R_24_t0 NB__t0 NB 1961.46264717
R_24_t1 NB__t1 NB 1980.02899168
R_24_t2 NB__t2 NB 3725.54776115
C_24 NB VSS 7.6112691e-14
R_25_t0 EC__t0 EC 1152.10022722
R_25_t1 EC__t1 EC 72.3260567335
R_25_t2 EC__t2 EC 340.597144123
R_25_t3 EC__t3 EC 212.391588062
R_25_t4 EC__t4 EC 275.91173659
R_25_t5 EC__t5 EC 246.208725544
R_25_t6 EC__t6 EC 72.3260567335
R_25_t7 EC__t7 EC 144.012528403
R_25_t8 EC__t8 EC 275.91173659
C_25 EC VSS 7.4190842e-14
R_26_t0 NZ__t0 NZ 1400.6452
R_26_t1 NZ__t1 NZ 1400.6452
C_26 NZ VSS 3.1064128e-14
R_27_t0 XRZ__2__t0 XRZ__2 9.125
R_27_t1 XRZ__2__t1 XRZ__2 9.125
C_27 XRZ__2 VSS 1.8067e-15
R_28_t0 XR2__14__t0 XR2__14 9.125
R_28_t1 XR2__14__t1 XR2__14 9.125
C_28 XR2__14 VSS 1.8067e-15
R_29_t0 XR2__12__t0 XR2__12 9.125
R_29_t1 XR2__12__t1 XR2__12 9.125
C_29 XR2__12 VSS 1.8067e-15
R_3_t0 PG__t0 PG 636.433597654
R_3_t1 PG__t1 PG 503.959749741
R_3_t2 PG__t2 PG 371.362761404
R_3_t3 PG__t3 PG 883.803713976
R_3_t4 PG__t4 PG 1322.79824296
R_3_t5 PG__t5 PG 238.945693911
R_3_t6 PG__t6 PG 546.299356917
R_3_t7 PG__t7 PG 591.351383441
C_3 PG VSS 7.8120649e-14
R_30_t0 XR2__10__t0 XR2__10 9.125
R_30_t1 XR2__10__t1 XR2__10 9.125
C_30 XR2__10 VSS 1.8067e-15
R_31_t0 XR2__8__t0 XR2__8 9.125
R_31_t1 XR2__8__t1 XR2__8 9.125
C_31 XR2__8 VSS 1.8067e-15
R_32_t0 XR2__6__t0 XR2__6 9.125
R_32_t1 XR2__6__t1 XR2__6 9.125
C_32 XR2__6 VSS 1.8067e-15
R_33_t0 XR2__4__t0 XR2__4 9.125
R_33_t1 XR2__4__t1 XR2__4 9.125
C_33 XR2__4 VSS 1.8067e-15
R_34_t0 XR2__2__t0 XR2__2 9.125
R_34_t1 XR2__2__t1 XR2__2 9.125
C_34 XR2__2 VSS 1.8067e-15
R_35_t0 XRT__1__t0 XRT__1 9.125
R_35_t1 XRT__1__t1 XRT__1 9.125
C_35 XRT__1 VSS 1.8067e-15
R_36_t0 ER__t0 ER 1393.837
R_36_t1 ER__t1 ER 1393.837
C_36 ER VSS 3.3170077e-14
R_37_t0 XR1__1__t0 XR1__1 9.125
R_37_t1 XR1__1__t1 XR1__1 9.125
C_37 XR1__1 VSS 1.8067e-15
R_38_t0 XRZ__3__t0 XRZ__3 9.125
R_38_t1 XRZ__3__t1 XRZ__3 9.125
C_38 XRZ__3 VSS 1.8067e-15
R_39_t0 XRZ__1__t0 XRZ__1 9.125
R_39_t1 XRZ__1__t1 XRZ__1 9.125
C_39 XRZ__1 VSS 1.8067e-15
R_4_t0 NA__t0 NA 2219.38475185
R_4_t1 NA__t1 NA 1234.10052238
R_4_t2 NA__t2 NA 3997.24029431
R_4_t3 NA__t3 NA 557.864231464
C_4 NA VSS 8.7584412e-14
R_40_t0 XR2__7__t0 XR2__7 9.125
R_40_t1 XR2__7__t1 XR2__7 9.125
C_40 XR2__7 VSS 1.8067e-15
R_41_t0 XR2__5__t0 XR2__5 9.125
R_41_t1 XR2__5__t1 XR2__5 9.125
C_41 XR2__5 VSS 1.8067e-15
R_42_t0 XR2__3__t0 XR2__3 9.125
R_42_t1 XR2__3__t1 XR2__3 9.125
C_42 XR2__3 VSS 1.8067e-15
R_43_t0 XR2__1__t0 XR2__1 9.125
R_43_t1 XR2__1__t1 XR2__1 9.125
C_43 XR2__1 VSS 1.8067e-15
R_44_t0 XR2__15__t0 XR2__15 9.125
R_44_t1 XR2__15__t1 XR2__15 9.125
C_44 XR2__15 VSS 1.8067e-15
R_45_t0 XR2__13__t0 XR2__13 9.125
R_45_t1 XR2__13__t1 XR2__13 9.125
C_45 XR2__13 VSS 1.8067e-15
R_46_t0 XR2__11__t0 XR2__11 9.125
R_46_t1 XR2__11__t1 XR2__11 9.125
C_46 XR2__11 VSS 1.8067e-15
R_47_t0 XR2__9__t0 XR2__9 9.125
R_47_t1 XR2__9__t1 XR2__9 9.125
C_47 XR2__9 VSS 1.8067e-15
R_5_t0 NBTOP__t0 NBTOP 3898.24002795
R_5_t1 NBTOP__t1 NBTOP 2571.04128444
R_5_t2 NBTOP__t2 NBTOP 1327.4843876
C_5 NBTOP VSS 7.8319844e-14
R_7_t0 NBG__t0 NBG 2435.8789
R_7_t1 NBG__t1 NBG 734.293929275
R_7_t2 NBG__t2 NBG 967.291041449
R_7_t3 NBG__t3 NBG 734.293929275
C_7 NBG VSS 5.5851412e-14
R_8_t0 PB__t0 PB 732.273832504
R_8_t1 PB__t1 PB 171.628406437
R_8_t2 PB__t2 PB 1341.19339542
R_8_t3 PB__t3 PB 783.709475137
R_8_t4 PB__t4 PB 321.870246222
R_8_t5 PB__t5 PB 769.394856997
R_8_t6 PB__t6 PB 46.1556265021
R_8_t7 PB__t7 PB 460.379603783
R_8_t8 PB__t8 PB 769.394856997
C_8 PB VSS 7.9168117e-14
RBIAS_OK_t0 BIAS_OK__t0 BIAS_OK 2339.5192
RBIAS_OK_t1 BIAS_OK__t1 BIAS_OK 2339.5192
CBIAS_OK BIAS_OK VSS 4.7753184e-14
RIBIAS_t0 IBIAS__t0 IBIAS 4663.4113
CIBIAS IBIAS VSS 4.1483963e-14
RVDD_t0 VDD__t0 VDD 18.3490381511
RVDD_t1 VDD__t1 VDD 18.3490381511
RVDD_t2 VDD__t2 VDD 12.5597109297
RVDD_t3 VDD__t3 VDD 12.5597109297
RVDD_t4 VDD__t4 VDD 9.59042869478
RVDD_t5 VDD__t5 VDD 9.59042869478
RVDD_t6 VDD__t6 VDD 4.73655855287
RVDD_t7 VDD__t7 VDD 1.89786481854
RVDD_t8 VDD__t8 VDD 1.89786481854
RVDD_t9 VDD__t9 VDD 70.0069054947
RVDD_t10 VDD__t10 VDD 28.0088605711
RVDD_t11 VDD__t11 VDD 28.0088605711
RVDD_t12 VDD__t12 VDD 9.10556563512
RVDD_t13 VDD__t13 VDD 11.0357462885
RVDD_t14 VDD__t14 VDD 3.46407886324
RVDD_t15 VDD__t15 VDD 9.10556563512
RVDD_t16 VDD__t16 VDD 11.0357462885
RVDD_t17 VDD__t17 VDD 3.46407886324
RVDD_t18 VDD__t18 VDD 2.82384916305
RVDD_t19 VDD__t19 VDD 1.55071553575
RVDD_t20 VDD__t20 VDD 6.76663189187
RVDD_t21 VDD__t21 VDD 10.6210666462
RVDD_t22 VDD__t22 VDD 1.55071553575
RVDD_t23 VDD__t23 VDD 6.76663189187
RVDD_t24 VDD__t24 VDD 10.6210666462
RVDD_t25 VDD__t25 VDD 7.04564561945
RVDD_t26 VDD__t26 VDD 5.09940792054
RVDD_t27 VDD__t27 VDD 14.4468201801
RVDD_t28 VDD__t28 VDD 16.3978384187
RVDD_t29 VDD__t29 VDD 14.4468201801
RVDD_t30 VDD__t30 VDD 16.3978384187
CVDD VDD VSS 1.50745094e-13
RVREF_t0 VREF__t0 VREF 3847.79075
RVREF_t1 VREF__t1 VREF 3847.79075
CVREF VREF VSS 7.3507489e-14
RVSS_t0 VSS__t0 VSS 3.62269552421
RVSS_t1 VSS__t1 VSS 3.3142902479
RVSS_t2 VSS__t2 VSS 2.88296407502
RVSS_t3 VSS__t3 VSS 1.61606765031
RVSS_t4 VSS__t4 VSS 1.55518591813
RVSS_t5 VSS__t5 VSS 1.28720407093
RVSS_t6 VSS__t6 VSS 1.15492128112
RVSS_t7 VSS__t7 VSS 0.046541739734
RVSS_t8 VSS__t8 VSS 0.707450333327
RVSS_t9 VSS__t9 VSS 0.668726372543
RVSS_t10 VSS__t10 VSS 0.905709610457
RVSS_t11 VSS__t11 VSS 0.356890791398
RVSS_t12 VSS__t12 VSS 0.465423457835
RVSS_t13 VSS__t13 VSS 0.732422637179
RVSS_t14 VSS__t14 VSS 0.612601885956
RVSS_t15 VSS__t15 VSS 0.302347633786
RVSS_t16 VSS__t16 VSS 0.989430125904
RVSS_t17 VSS__t17 VSS 3.1048655595
RVSS_t18 VSS__t18 VSS 3.49123124431
RVSS_t19 VSS__t19 VSS 1.76382681958
RVSS_t20 VSS__t20 VSS 1.44804434787
RVSS_t21 VSS__t21 VSS 1.22563529906
RVSS_t22 VSS__t22 VSS 1.35429122161
RVSS_t23 VSS__t23 VSS 0.668726372543
RVSS_t24 VSS__t24 VSS 0.732422637179
RVSS_t25 VSS__t25 VSS 0.905709610457
RVSS_t26 VSS__t26 VSS 0.356890791398
RVSS_t27 VSS__t27 VSS 0.465423457835
RVSS_t28 VSS__t28 VSS 0.707450333327
RVSS_t29 VSS__t29 VSS 0.989430125904
RVSS_t30 VSS__t30 VSS 0.046541739734
RVSS_t31 VSS__t31 VSS 0.302347633786
RVSS_t32 VSS__t32 VSS 0.612601885956
RVSS_t33 VSS__t33 VSS 2.30792864672
RVSS_t34 VSS__t34 VSS 2.34411808708
RVSS_t35 VSS__t35 VSS 2.41970118491
RVSS_t36 VSS__t36 VSS 2.49923129895
RVSS_t37 VSS__t37 VSS 2.58234377852
RVSS_t38 VSS__t38 VSS 2.6687039436
RVSS_t39 VSS__t39 VSS 2.75800673132
RVSS_t40 VSS__t40 VSS 2.84997553758
RVSS_t41 VSS__t41 VSS 2.38139231014
RVSS_t42 VSS__t42 VSS 2.45899635513
RVSS_t43 VSS__t43 VSS 2.54036136359
RVSS_t44 VSS__t44 VSS 2.6251376505
RVSS_t45 VSS__t45 VSS 2.71300544671
RVSS_t46 VSS__t46 VSS 2.80367410143
RVSS_t47 VSS__t47 VSS 2.89688063673
RVSS_t48 VSS__t48 VSS 2.94436054908
RVSS_t49 VSS__t49 VSS 3.04119063361
RVSS_t50 VSS__t50 VSS 3.09065224382
RVSS_t51 VSS__t51 VSS 3.14057429069
RVSS_t52 VSS__t52 VSS 3.19093516376
RVSS_t53 VSS__t53 VSS 2.92596660779
RVSS_t54 VSS__t54 VSS 2.9843073127
RVSS_t55 VSS__t55 VSS 3.01812698801
RVSS_t56 VSS__t56 VSS 3.07893638539
RVSS_t57 VSS__t57 VSS 2.70306155616
RVSS_t58 VSS__t58 VSS 2.50075534872
RVSS_t59 VSS__t59 VSS 2.30178219345
RVSS_t60 VSS__t60 VSS 2.10708652698
RVSS_t61 VSS__t61 VSS 1.91797143161
RVSS_t62 VSS__t62 VSS 1.55518591813
RVSS_t63 VSS__t63 VSS 3.62269552421
RVSS_t64 VSS__t64 VSS 3.49123124431
RVSS_t65 VSS__t65 VSS 1.76382681958
RVSS_t66 VSS__t66 VSS 1.44804434787
RVSS_t67 VSS__t67 VSS 1.35429122161
RVSS_t68 VSS__t68 VSS 1.22563529906
RVSS_t69 VSS__t69 VSS 1.28720407093
RVSS_t70 VSS__t70 VSS 3.3142902479
RVSS_t71 VSS__t71 VSS 3.1048655595
RVSS_t72 VSS__t72 VSS 1.15492128112
RVSS_t73 VSS__t73 VSS 2.88296407502
RVSS_t74 VSS__t74 VSS 1.61606765031
CVSS VSS VSS 2.53061568e-13
Ccc__12__3 N2 PG 1.1805e-17
Ccc__17__26 NOKX NZ 1.4757e-17
Ccc__17__3 NOKX PG 1.4757e-17
Ccc__17_VDD NOKX VDD 7.7718e-17
Ccc__24__3 NB PG 1.1805e-17
Ccc__25__3 EC PG 1.5347e-16
Ccc__26__3 NZ PG 2.30203e-16
Ccc__3__4 PG NA 1.1805e-17
Ccc__3__5 PG NBTOP 1.1805e-17
Ccc__3_VREF PG VREF 1.1805e-17
Ccc__3_VSS PG VSS 3.5416e-17
Rvsubs_dctie VSS 0 1e+12
.ends bias_core
