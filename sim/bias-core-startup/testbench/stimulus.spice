* bias-core-startup -- stimulus half of the testbench fragment.
*
* The other half is a verbatim copy of design/netlist/bias_core.spice,
* appended by sim/build_tb.py to produce tb_bias_core_startup.spice. Edit
* THIS file (or the schematic), never the generated fragment.
*
* Netlist FRAGMENT: no .include / .lib / .temp / .control / .end -- the
* harness owns those. Parameters it supplies: vdd_val, vdd_nom, temp_c.
*
* A QUASI-STATIC RAIL SWEEP, not a transient. The analysis is a DC sweep of
* the DUT's own supply from 0 V to 3.63 V in 2 mV steps, and ngspice seeds
* each step's Newton solve with the previous step's solution -- so the sweep
* tracks the branch a real, arbitrarily slow ramp would sit on, and it will
* stay on a wrong branch if one exists. That is exactly the property this
* experiment needs, and it is why the sweep is the primary startup-ordering
* evidence rather than one transient at one arbitrary ramp rate:
*
*   - A transient always starts from 0 V with every node at 0, so it visits
*     one trajectory. A branch-tracking DC sweep visits the whole rail range
*     and reports where the circuit actually sits at each rail.
*   - The result is RAMP-RATE INDEPENDENT. spec/target-spec.md#por-ramp-rate
*     ratifies a 1 V/s ... 1 V/us envelope and assigns sweeping it (both
*     endpoints plus a decade inside each) to #14. Picking one rate here
*     would produce a number #14 has to redo; the quasi-static limit is the
*     one statement that is true for every rate in the envelope.
*   - The DEAD-state half of the claim -- that the degenerate zero-current
*     solution is not stable anywhere on the grid -- is covered separately,
*     and more strongly, by sim/bias-core-designer-check/'s `vref_dead_v`,
*     which seeds the DC solve IN that state at all 81 points.
*
* This sweep caught a real defect during design: an earlier revision of the
* startup detector (a native-device pull-UP on a sensed node, so that the
* node's own rise turned the pull-up off through the body effect) tracked a
* second, high-current branch with VREF pinned near VDD - 0.2 V from 1.4 V of
* rail all the way to 3.3 V at ss/-40 C. A per-point `op` at 2.97/3.30/3.63 V
* converged to the correct solution and showed none of it. See
* design/bias_core.md, "Startup".
*
* The supply axis of the PVT grid is deliberately degenerate for this
* experiment: a rail sweep passes through 2.97, 3.30 and 3.63 V on its way up,
* so the three supply points of the mandated grid produce identical curves by
* construction. The grid is still run in full -- the record must not claim a
* subset -- and no spread-based check is used on any measurement here.
*
* IBIAS carries the same consumer-diode replica load the other two bias_core
* experiments use (temp_core's XMBD 4u/2u and por_comparator's XMBD 2u/2u,
* verbatim from the exported netlists).

vramp vdd 0 dc 0
xdut vdd 0 ibsrc vref bias_ok bias_core
vib ibsrc ibias dc 0
xldt ibias ibias 0 0 nfet_03v3 L=2u W=4u nf=1 m=1
xldc ibias ibias 0 0 nfet_03v3 L=2u W=2u nf=1 m=1
