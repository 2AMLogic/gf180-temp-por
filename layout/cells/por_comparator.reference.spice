* por_comparator -- klt lvs reference netlist
* generated by layout/lvs_reference.py from design/netlist/por_comparator.spice
* Do not edit: edit the schematic, re-run design/netlist.py, re-run this.
.SUBCKT por_comparator BIAS_OK BIAS_OKB IBIAS POR_RAW VDD VREF VSS vsubs
M1 BIAS_OKB BIAS_OK VSS vsubs nfet L=0.5U W=1U
M2 BIAS_OKB BIAS_OK VDD NW2 pfet L=0.5U W=2U
M3 NA NA VDDA NW1 pfet L=1U W=4U
M4 CMPO NA VDDA NW1 pfet L=1U W=4U
M5 VDDA BIAS_OKB VDD NW1 pfet L=0.5U W=4U
M6 N1 CMPO VDD NW1 pfet L=0.5U W=2U
M7 POR_RAW N1 VDD NW1 pfet L=0.5U W=2U
M8 NA SNS TN vsubs nfet L=1U W=2U
M9 CMPO VREF TN vsubs nfet L=1U W=2U
M10 TN NBG VSS vsubs nfet L=10U W=1U
M11 IBIAS NBG VSS vsubs nfet L=2U W=2U
M12 IBIAS BIAS_OK NBG vsubs nfet L=0.5U W=2U
M13 NBG BIAS_OKB VSS vsubs nfet L=0.5U W=2U
M14 IBIAS BIAS_OKB VSS vsubs nfet L=1U W=1U
M15 SNSB N1 VSS vsubs nfet L=0.5U W=10U
M16 CMPO BIAS_OKB VSS vsubs nfet L=1U W=2U
M17 N1 CMPO VSS vsubs nfet L=0.5U W=1U
M18 POR_RAW N1 VSS vsubs nfet L=0.5U W=1U
.ENDS por_comparator
