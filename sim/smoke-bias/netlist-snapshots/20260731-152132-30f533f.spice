* Frozen netlist snapshot for record 20260731-152132-30f533f
* source     : sim/smoke-bias/testbench/smoke_bias.spice
* sha256     : def6c4616d47f1d2b45c5c3cf045c450504cc6bcfe07ade2e4b5e6925f5211cd
* This is a verbatim copy taken at record time. Do not edit.
* smoke_bias -- harness acceptance testbench (NOT a temp sensor, NOT a POR)
*
* Netlist FRAGMENT. The harness supplies the title, .include of the gf180mcu
* models, the corner .lib sections, .temp, the .control block and .end.
* Parameters provided by the harness: vdd_val, vdd_nom, temp_c.
*
* Three deliberately independent branches, each proving a different piece of
* the harness is wired up, and each exercising a device family this block
* actually depends on:
*
*   1. ideal resistive divider  -> parameter plumbing; must be PVT-invariant
*                                  (the POR threshold tap is a divider off VDD)
*   2. PDK poly resistor + diode-connected nfet_03v3 -> MOS and res corners
*                                  (bias legs and the comparator input pair)
*   3. diode-connected vertical PNP at 10 uA -> BJT corner and temperature
*                                  (the PTAT/CTAT core's CTAT element)
*
* Branch 3 is the temperature probe: Veb is strongly CTAT (~ -2 mV/degC),
* so a flat vbe across the grid means .temp never took effect.

vsup vdd 0 dc {vdd_val}

* --- 1. ideal divider: exactly vdd/2 at every corner, temperature and supply
Rtop vdd ndiv 100k
Rbot ndiv 0   100k

* --- 2. PDK unsalicided p+ poly resistor into a diode-connected 3.3 V nfet
XR1 vdd nbias 0    ppolyf_u r_width=1u r_length=100u
XM1 nbias nbias 0 0 nfet_03v3 w=10u l=1u

* --- 3. diode-connected vertical PNP, forced 10 uA into the emitter (c b e)
*     Base and collector both to substrate: the standard gf180mcu vertical-PNP
*     diode connection, and the same device the sensing core's CTAT leg uses.
Iq 0 nbe dc 10u
XQ1 0 0 nbe pnp_10p00x10p00
