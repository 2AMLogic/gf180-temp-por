* temp_core -- post-layout netlist
* GENERATED by layout/postlayout.py -- do not edit.
*
* FROM THE LAYOUT: every device and its dimensions, the whole
*   topology, and first-order interconnect R/C on 69/69 nets
*   (sigma 1740.7 fF, of which 3.071 fF is net-to-net coupling).
*   One star per net: <net> is the hub, <net>__t<k> each device
*   terminal on it, R<net>_t<k> the arm between them.
*   klt 0.6.0, deck gf180mcu,
*   GDS sha256 ffcb31808d178846...
* Net names are the schematic's, restored through klt lvs's own net
*   correspondence -- match, 69/69 nets, every one paired.
*
* NOT FROM THE LAYOUT -- see layout/postlayout/AUDIT.md:
*   4 body/plate net(s) tied to the net the schematic puts
*   them on. The extraction deck's connectivity stack does not reach
*   an Nwell, a substrate ring, a bipolar base well or a MiM plate,
*   so they extract isolated and would otherwise float.
*   No ideal device: every golden device is drawn.
*
.subckt temp_core VDD VSS IBIAS EN PTAT CTAT

* --- drawn devices ---
X1 VSS__t87 VSS__t88 VSS__t86 VSS__t59 nfet_03v3 L=8u W=4u nf=1 ad=3.2p as=3.2p pd=9.6u ps=9.6u m=1
X2 N1__t7 N1__t5 VSS__t119 VSS__t60 nfet_03v3 L=8u W=4u nf=1 ad=3.2p as=3.2p pd=9.6u ps=9.6u m=1
X3 N2__t5 N1__t2 VSS__t115 VSS__t61 nfet_03v3 L=8u W=4u nf=1 ad=3.2p as=3.2p pd=9.6u ps=9.6u m=1
X4 N2__t6 N1__t3 VSS__t116 VSS__t62 nfet_03v3 L=8u W=4u nf=1 ad=3.2p as=3.2p pd=9.6u ps=9.6u m=1
X5 N1__t6 N1__t4 VSS__t117 VSS__t63 nfet_03v3 L=8u W=4u nf=1 ad=3.2p as=3.2p pd=9.6u ps=9.6u m=1
X6 VSS__t114 VSS__t113 VSS__t118 VSS__t64 nfet_03v3 L=8u W=4u nf=1 ad=3.2p as=3.2p pd=9.6u ps=9.6u m=1
X7 PG__t0 N2__t0 VSS__t89 VSS__t65 nfet_03v3 L=8u W=8u nf=1 ad=6.4p as=6.4p pd=17.6u ps=17.6u m=1
X8 IBIAS__t1 NBG__t0 VSS__t90 VSS__t66 nfet_03v3 L=2u W=4u nf=1 ad=3.2p as=3.2p pd=9.6u ps=9.6u m=1
X9 IBIAS__t0 EN__t0 NBG__t2 VSS__t69 nfet_03v3 L=0.5u W=2u nf=1 ad=1.6p as=1.6p pd=5.6u ps=5.6u m=1
X10 NBG__t1 ENB__t6 VSS__t92 VSS__t70 nfet_03v3 L=0.5u W=2u nf=1 ad=1.6p as=1.6p pd=5.6u ps=5.6u m=1
X11 PB__t5 NBG__t4 VSS__t112 VSS__t67 nfet_03v3 L=2u W=4u nf=1 ad=3.2p as=3.2p pd=9.6u ps=9.6u m=1
X12 PCAS__t0 NBG__t3 VSS__t111 VSS__t68 nfet_03v3 L=2u W=4u nf=1 ad=3.2p as=3.2p pd=9.6u ps=9.6u m=1
X13 ENB__t0 EN__t1 VSS__t93 VSS__t72 nfet_03v3 L=0.5u W=1u nf=1 ad=0.8p as=0.8p pd=3.6u ps=3.6u m=1
X14 ND__t1 NR__t0 VSS__t94 VSS__t73 nfet_03v3 L=2u W=2u nf=1 ad=1.6p as=1.6p pd=5.6u ps=5.6u m=1
X15 PG__t1 ND__t0 VSS__t91 VSS__t75 nfet_03v3 L=1u W=4u nf=1 ad=3.2p as=3.2p pd=9.6u ps=9.6u m=1
X16 NR__t3 NR__t2 VSS__t109 VSS__t74 nfet_03v3 L=2u W=2u nf=1 ad=1.6p as=1.6p pd=5.6u ps=5.6u m=1
X17 ND__t3 ENB__t7 VSS__t110 VSS__t71 nfet_03v3 L=0.5u W=2u nf=1 ad=1.6p as=1.6p pd=5.6u ps=5.6u m=1
X18 PTAT__t0 ENB__t1 VSS__t95 VSS__t76 nfet_03v3 L=1u W=1u nf=1 ad=0.8p as=0.8p pd=3.6u ps=3.6u m=1
X19 CTAT__t1 ENB__t5 VSS__t108 VSS__t77 nfet_03v3 L=1u W=1u nf=1 ad=0.8p as=0.8p pd=3.6u ps=3.6u m=1
X20 N2__t1 ENB__t2 VSS__t96 VSS__t78 nfet_03v3 L=1u W=2u nf=1 ad=1.6p as=1.6p pd=5.6u ps=5.6u m=1
X21 NT__t17 ENB__t4 VSS__t107 VSS__t79 nfet_03v3 L=1u W=2u nf=1 ad=1.6p as=1.6p pd=5.6u ps=5.6u m=1
X22 T5__t0 VDD__t0 T4__t0 VSS__t80 nfet_03v3 L=0.5u W=32u nf=1 ad=25.6p as=25.6p pd=65.6u ps=65.6u m=1
X23 T3__t2 VSS__t121 T2__t3 VSS__t81 nfet_03v3 L=0.5u W=32u nf=1 ad=25.6p as=25.6p pd=65.6u ps=65.6u m=1
X24 T1__t2 VSS__t122 T0__t3 VSS__t82 nfet_03v3 L=0.5u W=32u nf=1 ad=25.6p as=25.6p pd=65.6u ps=65.6u m=1
X25 T0__t2 VSS__t123 VSS__t120 VSS__t83 nfet_03v3 L=0.5u W=32u nf=1 ad=25.6p as=25.6p pd=65.6u ps=65.6u m=1
X26 T2__t2 VSS__t124 T1__t3 VSS__t84 nfet_03v3 L=0.5u W=32u nf=1 ad=25.6p as=25.6p pd=65.6u ps=65.6u m=1
X27 T4__t3 VSS__t125 T3__t3 VSS__t85 nfet_03v3 L=0.5u W=32u nf=1 ad=25.6p as=25.6p pd=65.6u ps=65.6u m=1
X28 NT__t1 NT__t2 NT__t0 NT__t3 pfet_03v3 L=4u W=16u nf=1 ad=12.8p as=12.8p pd=33.6u ps=33.6u m=1
X29 N1__t0 NA__t4 NT__t12 NT__t5 pfet_03v3 L=4u W=16u nf=1 ad=12.8p as=12.8p pd=33.6u ps=33.6u m=1
X30 N2__t4 NB__t4 NT__t16 NT__t9 pfet_03v3 L=4u W=16u nf=1 ad=12.8p as=12.8p pd=33.6u ps=33.6u m=1
X31 N2__t3 NB__t3 NT__t15 NT__t8 pfet_03v3 L=4u W=16u nf=1 ad=12.8p as=12.8p pd=33.6u ps=33.6u m=1
X32 N1__t1 NA__t5 NT__t14 NT__t7 pfet_03v3 L=4u W=16u nf=1 ad=12.8p as=12.8p pd=33.6u ps=33.6u m=1
X33 NT__t11 NT__t10 NT__t13 NT__t6 pfet_03v3 L=4u W=16u nf=1 ad=12.8p as=12.8p pd=33.6u ps=33.6u m=1
X34 NT__t4 PB__t0 VDD__t1 VDD__t2 pfet_03v3 L=4u W=20u nf=1 ad=16p as=16p pd=41.6u ps=41.6u m=1
X35 VDD__t4 VDD__t5 VDD__t3 VDD__t6 pfet_03v3 L=4u W=4u nf=1 ad=3.2p as=3.2p pd=9.6u ps=9.6u m=1
X36 M1D__t3 PG__t9 VDD__t39 VDD__t30 pfet_03v3 L=4u W=4u nf=1 ad=3.2p as=3.2p pd=9.6u ps=9.6u m=1
X37 NA__t0 PCAS__t1 M1D__t0 VDD__t7 pfet_03v3 L=1u W=4u nf=1 ad=3.2p as=3.2p pd=9.6u ps=9.6u m=1
X38 M2D__t3 PG__t11 VDD__t41 VDD__t32 pfet_03v3 L=4u W=4u nf=1 ad=3.2p as=3.2p pd=9.6u ps=9.6u m=1
X39 NB__t2 PCAS__t8 M2D__t1 VDD__t26 pfet_03v3 L=1u W=4u nf=1 ad=3.2p as=3.2p pd=9.6u ps=9.6u m=1
X40 M3D__t3 PG__t10 VDD__t40 VDD__t31 pfet_03v3 L=4u W=4u nf=1 ad=3.2p as=3.2p pd=9.6u ps=9.6u m=1
X41 PTAT__t3 PCAS__t7 M3D__t1 VDD__t25 pfet_03v3 L=1u W=4u nf=1 ad=3.2p as=3.2p pd=9.6u ps=9.6u m=1
X42 PTAT__t2 PCAS__t6 M3D__t0 VDD__t24 pfet_03v3 L=1u W=4u nf=1 ad=3.2p as=3.2p pd=9.6u ps=9.6u m=1
X43 M3D__t2 PG__t8 VDD__t38 VDD__t29 pfet_03v3 L=4u W=4u nf=1 ad=3.2p as=3.2p pd=9.6u ps=9.6u m=1
X44 NB__t1 PCAS__t4 M2D__t0 VDD__t22 pfet_03v3 L=1u W=4u nf=1 ad=3.2p as=3.2p pd=9.6u ps=9.6u m=1
X45 M2D__t2 PG__t7 VDD__t37 VDD__t28 pfet_03v3 L=4u W=4u nf=1 ad=3.2p as=3.2p pd=9.6u ps=9.6u m=1
X46 NA__t3 PCAS__t5 M1D__t1 VDD__t23 pfet_03v3 L=1u W=4u nf=1 ad=3.2p as=3.2p pd=9.6u ps=9.6u m=1
X47 M1D__t2 PG__t6 VDD__t36 VDD__t27 pfet_03v3 L=4u W=4u nf=1 ad=3.2p as=3.2p pd=9.6u ps=9.6u m=1
X48 VDD__t35 VDD__t34 VDD__t42 VDD__t33 pfet_03v3 L=4u W=4u nf=1 ad=3.2p as=3.2p pd=9.6u ps=9.6u m=1
X49 PG__t2 PB__t1 VDD__t8 VDD__t9 pfet_03v3 L=4u W=10u nf=1 ad=8p as=8p pd=21.6u ps=21.6u m=1
X50 PB__t4 PB__t3 VDD__t21 VDD__t20 pfet_03v3 L=4u W=10u nf=1 ad=8p as=8p pd=21.6u ps=21.6u m=1
X51 PCAS__t2 PCAS__t3 VDD__t10 VDD__t11 pfet_03v3 L=8u W=1u nf=1 ad=0.8p as=0.8p pd=3.6u ps=3.6u m=1
X52 ENB__t3 EN__t2 VDD__t12 VDD__t13 pfet_03v3 L=0.5u W=2u nf=1 ad=1.6p as=1.6p pd=5.6u ps=5.6u m=1
X53 ND__t2 PB__t2 VDD__t19 VDD__t18 pfet_03v3 L=8u W=1u nf=1 ad=0.8p as=0.8p pd=3.6u ps=3.6u m=1
X54 NR__t1 PG__t3 VDD__t14 VDD__t15 pfet_03v3 L=4u W=1u nf=1 ad=0.8p as=0.8p pd=3.6u ps=3.6u m=1
X55 PG__t4 EN__t3 VDD__t16 VDD__t17 pfet_03v3 L=0.5u W=4u nf=1 ad=3.2p as=3.2p pd=9.6u ps=9.6u m=1
X56 VSS__t0 VSS__t97 NC__t1 pnp_10p00x10p00
X57 VSS__t1 VSS__t105 NC__t8 pnp_10p00x10p00
X58 VSS__t2 VSS__t98 NC__t2 pnp_10p00x10p00
X59 VSS__t3 VSS__t99 NC__t3 pnp_10p00x10p00
X60 VSS__t4 VSS__t100 NA__t2 pnp_10p00x10p00
X61 VSS__t5 VSS__t101 NC__t4 pnp_10p00x10p00
X62 VSS__t6 VSS__t102 NC__t5 pnp_10p00x10p00
X63 VSS__t7 VSS__t103 NC__t6 pnp_10p00x10p00
X64 VSS__t8 VSS__t104 NC__t7 pnp_10p00x10p00
X65 PG__t5 NZ__t1 cap_mim_2f0_m3m4_noshield c_width=12u c_length=12u
X66 NB__t0 XR1__1__t0 VSS__t9 ppolyf_u r_width=2u r_length=59.735u
X67 NC__t0 XR1__1__t1 VSS__t10 ppolyf_u r_width=2u r_length=59.735u
X68 NA__t1 XRISO__1__t0 VSS__t11 ppolyf_u r_width=2u r_length=55.525u
X69 CTAT__t0 XRISO__1__t1 VSS__t12 ppolyf_u r_width=2u r_length=55.525u
X70 NZ__t0 XRZ__1__t0 VSS__t13 ppolyf_u r_width=2u r_length=100u
X71 XRZ__2__t0 XRZ__1__t1 VSS__t14 ppolyf_u r_width=2u r_length=100u
X72 XRZ__2__t1 XRZ__3__t1 VSS__t15 ppolyf_u r_width=2u r_length=100u
X73 XRZ__4__t1 XRZ__3__t0 VSS__t16 ppolyf_u r_width=2u r_length=100u
X74 XRZ__4__t0 XRZ__5__t1 VSS__t17 ppolyf_u r_width=2u r_length=100u
X75 XRZ__6__t1 XRZ__5__t0 VSS__t18 ppolyf_u r_width=2u r_length=100u
X76 XRZ__6__t0 XRZ__7__t1 VSS__t19 ppolyf_u r_width=2u r_length=100u
X77 XRZ__8__t1 XRZ__7__t0 VSS__t20 ppolyf_u r_width=2u r_length=100u
X78 XRZ__8__t0 XRZ__9__t1 VSS__t21 ppolyf_u r_width=2u r_length=100u
X79 N2__t2 XRZ__9__t0 VSS__t22 ppolyf_u r_width=2u r_length=100u
X80 PTAT__t1 XR2F__1__t0 VSS__t23 ppolyf_u r_width=2u r_length=110.525u
X81 XR2F__2__t1 XR2F__1__t1 VSS__t24 ppolyf_u r_width=2u r_length=110.525u
X82 XR2F__2__t0 XR2F__3__t1 VSS__t25 ppolyf_u r_width=2u r_length=110.525u
X83 XR2F__4__t1 XR2F__3__t0 VSS__t26 ppolyf_u r_width=2u r_length=110.525u
X84 XR2F__4__t0 XR2F__5__t1 VSS__t27 ppolyf_u r_width=2u r_length=110.525u
X85 XR2F__6__t1 XR2F__5__t0 VSS__t28 ppolyf_u r_width=2u r_length=110.525u
X86 XR2F__6__t0 XR2F__7__t1 VSS__t29 ppolyf_u r_width=2u r_length=110.525u
X87 XR2F__8__t1 XR2F__7__t0 VSS__t30 ppolyf_u r_width=2u r_length=110.525u
X88 XR2F__8__t0 XR2F__9__t1 VSS__t31 ppolyf_u r_width=2u r_length=110.525u
X89 XR2F__10__t1 XR2F__9__t0 VSS__t32 ppolyf_u r_width=2u r_length=110.525u
X90 XR2F__10__t0 XR2F__11__t1 VSS__t33 ppolyf_u r_width=2u r_length=110.525u
X91 XR2F__12__t1 XR2F__11__t0 VSS__t34 ppolyf_u r_width=2u r_length=110.525u
X92 XR2F__12__t0 XR2F__13__t1 VSS__t35 ppolyf_u r_width=2u r_length=110.525u
X93 XR2F__14__t1 XR2F__13__t0 VSS__t36 ppolyf_u r_width=2u r_length=110.525u
X94 XR2F__14__t0 XR2F__15__t1 VSS__t37 ppolyf_u r_width=2u r_length=110.525u
X95 XR2F__16__t1 XR2F__15__t0 VSS__t38 ppolyf_u r_width=2u r_length=110.525u
X96 XR2F__16__t0 XR2F__17__t1 VSS__t39 ppolyf_u r_width=2u r_length=110.525u
X97 XR2F__18__t0 XR2F__17__t0 VSS__t40 ppolyf_u r_width=2u r_length=110.525u
X98 XR2F__18__t1 XR2F__19__t1 VSS__t41 ppolyf_u r_width=2u r_length=110.525u
X99 XR2F__20__t0 XR2F__19__t0 VSS__t42 ppolyf_u r_width=2u r_length=110.525u
X100 XR2F__20__t1 XR2F__21__t0 VSS__t43 ppolyf_u r_width=2u r_length=110.525u
X101 XR2F__22__t0 XR2F__21__t1 VSS__t44 ppolyf_u r_width=2u r_length=110.525u
X102 XR2F__22__t1 XR2F__23__t0 VSS__t45 ppolyf_u r_width=2u r_length=110.525u
X103 T5__t2 XR2F__23__t1 VSS__t46 ppolyf_u r_width=2u r_length=110.525u
X104 T5__t1 XR2T5__1__t0 VSS__t47 ppolyf_u r_width=2u r_length=114.855u
X105 T4__t2 XR2T5__1__t1 VSS__t48 ppolyf_u r_width=2u r_length=114.855u
X106 T4__t1 XR2T4__1__t0 VSS__t49 ppolyf_u r_width=2u r_length=57.345u
X107 T3__t1 XR2T4__1__t1 VSS__t50 ppolyf_u r_width=2u r_length=57.345u
X108 T3__t0 XR2T3__1__t0 VSS__t51 ppolyf_u r_width=2u r_length=28.59u
X109 T2__t1 XR2T3__1__t1 VSS__t52 ppolyf_u r_width=2u r_length=28.59u
X110 T2__t0 XR2T2__1__t0 VSS__t53 ppolyf_u r_width=2u r_length=14.21u
X111 T1__t1 XR2T2__1__t1 VSS__t54 ppolyf_u r_width=2u r_length=14.21u
X112 T1__t0 XR2T1__1__t0 VSS__t55 ppolyf_u r_width=2u r_length=7.015u
X113 T0__t1 XR2T1__1__t1 VSS__t56 ppolyf_u r_width=2u r_length=7.015u
X114 T0__t0 XR2T0__1__t0 VSS__t57 ppolyf_u r_width=2u r_length=3.425u
X115 VSS__t106 XR2T0__1__t1 VSS__t58 ppolyf_u r_width=2u r_length=3.425u

R_28_t0 XRZ__2__t0 XRZ__2 25.28745
R_28_t1 XRZ__2__t1 XRZ__2 25.28745
C_28 XRZ__2 VSS 1.599507e-15
R_29_t0 XRZ__4__t0 XRZ__4 25.28745
R_29_t1 XRZ__4__t1 XRZ__4 25.28745
C_29 XRZ__4 VSS 1.599507e-15
R_30_t0 XRZ__6__t0 XRZ__6 25.28745
R_30_t1 XRZ__6__t1 XRZ__6 25.28745
C_30 XRZ__6 VSS 1.599507e-15
R_31_t0 XRZ__8__t0 XRZ__8 25.28745
R_31_t1 XRZ__8__t1 XRZ__8 25.28745
C_31 XRZ__8 VSS 1.599507e-15
R_32_t0 XR2F__2__t0 XR2F__2 25.28745
R_32_t1 XR2F__2__t1 XR2F__2 25.28745
C_32 XR2F__2 VSS 1.599507e-15
R_33_t0 XR2F__4__t0 XR2F__4 25.28745
R_33_t1 XR2F__4__t1 XR2F__4 25.28745
C_33 XR2F__4 VSS 1.599507e-15
R_34_t0 XR2F__6__t0 XR2F__6 25.28745
R_34_t1 XR2F__6__t1 XR2F__6 25.28745
C_34 XR2F__6 VSS 1.599507e-15
R_35_t0 XR2F__8__t0 XR2F__8 25.28745
R_35_t1 XR2F__8__t1 XR2F__8 25.28745
C_35 XR2F__8 VSS 1.599507e-15
R_36_t0 XR2F__10__t0 XR2F__10 25.28745
R_36_t1 XR2F__10__t1 XR2F__10 25.28745
C_36 XR2F__10 VSS 1.599507e-15
R_37_t0 XR2F__12__t0 XR2F__12 25.28745
R_37_t1 XR2F__12__t1 XR2F__12 25.28745
C_37 XR2F__12 VSS 1.599507e-15
R_38_t0 XR2F__14__t0 XR2F__14 25.28745
R_38_t1 XR2F__14__t1 XR2F__14 25.28745
C_38 XR2F__14 VSS 1.599507e-15
R_39_t0 XR2F__16__t0 XR2F__16 25.28745
R_39_t1 XR2F__16__t1 XR2F__16 25.28745
C_39 XR2F__16 VSS 1.599507e-15
R_40_t0 XR2F__18__t0 XR2F__18 25.28745
R_40_t1 XR2F__18__t1 XR2F__18 25.28745
C_40 XR2F__18 VSS 1.599507e-15
R_41_t0 XR2F__20__t0 XR2F__20 25.28745
R_41_t1 XR2F__20__t1 XR2F__20 25.28745
C_41 XR2F__20 VSS 1.599507e-15
R_42_t0 XR2F__22__t0 XR2F__22 25.28745
R_42_t1 XR2F__22__t1 XR2F__22 25.28745
C_42 XR2F__22 VSS 1.599507e-15
R_48_t0 XR2T0__1__t0 XR2T0__1 25.28745
R_48_t1 XR2T0__1__t1 XR2T0__1 25.28745
C_48 XR2T0__1 VSS 1.599507e-15
R_49_t0 XR2T1__1__t0 XR2T1__1 25.28745
R_49_t1 XR2T1__1__t1 XR2T1__1 25.28745
C_49 XR2T1__1 VSS 1.599507e-15
R_53_t0 XR2T2__1__t0 XR2T2__1 25.28745
R_53_t1 XR2T2__1__t1 XR2T2__1 25.28745
C_53 XR2T2__1 VSS 1.599507e-15
R_57_t0 XR2T3__1__t0 XR2T3__1 25.28745
R_57_t1 XR2T3__1__t1 XR2T3__1 25.28745
C_57 XR2T3__1 VSS 1.599507e-15
R_65_t0 XRISO__1__t0 XRISO__1 25.28745
R_65_t1 XRISO__1__t1 XRISO__1 25.28745
C_65 XRISO__1 VSS 1.599507e-15
R_66_t0 XR2T4__1__t0 XR2T4__1 25.28745
R_66_t1 XR2T4__1__t1 XR2T4__1 25.28745
C_66 XR2T4__1 VSS 1.599507e-15
R_67_t0 XR1__1__t0 XR1__1 25.28745
R_67_t1 XR1__1__t1 XR1__1 25.28745
C_67 XR1__1 VSS 1.599507e-15
R_68_t0 XRZ__1__t0 XRZ__1 25.28745
R_68_t1 XRZ__1__t1 XRZ__1 25.28745
C_68 XRZ__1 VSS 1.599507e-15
R_69_t0 XRZ__3__t0 XRZ__3 25.28745
R_69_t1 XRZ__3__t1 XRZ__3 25.28745
C_69 XRZ__3 VSS 1.599507e-15
R_70_t0 XRZ__5__t0 XRZ__5 25.28745
R_70_t1 XRZ__5__t1 XRZ__5 25.28745
C_70 XRZ__5 VSS 1.599507e-15
R_71_t0 XRZ__7__t0 XRZ__7 25.28745
R_71_t1 XRZ__7__t1 XRZ__7 25.28745
C_71 XRZ__7 VSS 1.599507e-15
R_72_t0 XRZ__9__t0 XRZ__9 25.28745
R_72_t1 XRZ__9__t1 XRZ__9 25.28745
C_72 XRZ__9 VSS 1.599507e-15
R_73_t0 XR2F__1__t0 XR2F__1 25.28745
R_73_t1 XR2F__1__t1 XR2F__1 25.28745
C_73 XR2F__1 VSS 1.599507e-15
R_74_t0 XR2F__3__t0 XR2F__3 25.28745
R_74_t1 XR2F__3__t1 XR2F__3 25.28745
C_74 XR2F__3 VSS 1.599507e-15
R_75_t0 XR2F__5__t0 XR2F__5 25.28745
R_75_t1 XR2F__5__t1 XR2F__5 25.28745
C_75 XR2F__5 VSS 1.599507e-15
R_76_t0 XR2F__7__t0 XR2F__7 25.28745
R_76_t1 XR2F__7__t1 XR2F__7 25.28745
C_76 XR2F__7 VSS 1.599507e-15
R_77_t0 XR2F__9__t0 XR2F__9 25.28745
R_77_t1 XR2F__9__t1 XR2F__9 25.28745
C_77 XR2F__9 VSS 1.599507e-15
R_78_t0 XR2F__11__t0 XR2F__11 25.28745
R_78_t1 XR2F__11__t1 XR2F__11 25.28745
C_78 XR2F__11 VSS 1.599507e-15
R_79_t0 XR2F__13__t0 XR2F__13 25.28745
R_79_t1 XR2F__13__t1 XR2F__13 25.28745
C_79 XR2F__13 VSS 1.599507e-15
R_80_t0 XR2F__15__t0 XR2F__15 25.28745
R_80_t1 XR2F__15__t1 XR2F__15 25.28745
C_80 XR2F__15 VSS 1.599507e-15
R_81_t0 XR2F__17__t0 XR2F__17 25.28745
R_81_t1 XR2F__17__t1 XR2F__17 25.28745
C_81 XR2F__17 VSS 1.599507e-15
R_82_t0 XR2F__19__t0 XR2F__19 25.28745
R_82_t1 XR2F__19__t1 XR2F__19 25.28745
C_82 XR2F__19 VSS 1.599507e-15
R_83_t0 XR2F__21__t0 XR2F__21 25.28745
R_83_t1 XR2F__21__t1 XR2F__21 25.28745
C_83 XR2F__21 VSS 1.599507e-15
R_84_t0 XR2F__23__t0 XR2F__23 25.28745
R_84_t1 XR2F__23__t1 XR2F__23 25.28745
C_84 XR2F__23 VSS 1.599507e-15
R_85_t0 XR2T5__1__t0 XR2T5__1 25.28745
R_85_t1 XR2T5__1__t1 XR2T5__1 25.28745
C_85 XR2T5__1 VSS 1.599507e-15
RCTAT_t0 CTAT__t0 CTAT 258.65425
RCTAT_t1 CTAT__t1 CTAT 258.65425
CCTAT CTAT VSS 3.5379154e-14
REN_t0 EN__t0 EN 488.922518209
REN_t1 EN__t1 EN 238.763338727
REN_t2 EN__t2 EN 236.947742703
REN_t3 EN__t3 EN 508.553700361
CEN EN VSS 3.3695736e-14
RENB_t0 ENB__t0 ENB 171.908381309
RENB_t1 ENB__t1 ENB 137.876093758
RENB_t2 ENB__t2 ENB 189.999228044
RENB_t3 ENB__t3 ENB 326.623923902
RENB_t4 ENB__t4 ENB 215.772604212
RENB_t5 ENB__t5 ENB 163.414676184
RENB_t6 ENB__t6 ENB 421.059618338
RENB_t7 ENB__t7 ENB 95.6628742538
CENB ENB VSS 3.6396628e-14
RIBIAS_t0 IBIAS__t0 IBIAS 161.3252
RIBIAS_t1 IBIAS__t1 IBIAS 161.3252
CIBIAS IBIAS VSS 2.0274985e-14
RM1D_t0 M1D__t0 M1D 297.344707753
RM1D_t1 M1D__t1 M1D 297.344707753
RM1D_t2 M1D__t2 M1D 365.905392247
RM1D_t3 M1D__t3 M1D 365.905392247
CM1D M1D VSS 2.6572254e-14
RM2D_t0 M2D__t0 M2D 257.619878352
RM2D_t1 M2D__t1 M2D 257.619878352
RM2D_t2 M2D__t2 M2D 367.857221648
RM2D_t3 M2D__t3 M2D 367.857221648
CM2D M2D VSS 2.5181332e-14
RM3D_t0 M3D__t0 M3D 118.304635714
RM3D_t1 M3D__t1 M3D 118.304635714
RM3D_t2 M3D__t2 M3D 469.402264286
RM3D_t3 M3D__t3 M3D 469.402264286
CM3D M3D VSS 2.3790409e-14
RN1_t0 N1__t0 N1 1046.59861862
RN1_t1 N1__t1 N1 801.166547704
RN1_t2 N1__t2 N1 243.963010283
RN1_t3 N1__t3 N1 378.085819054
RN1_t4 N1__t4 N1 534.627163629
RN1_t5 N1__t5 N1 188.503038543
RN1_t6 N1__t6 N1 534.627163629
RN1_t7 N1__t7 N1 188.503038543
CN1 N1 VSS 3.9158003e-14
RN2_t0 N2__t0 N2 145.839569879
RN2_t1 N2__t1 N2 392.018582259
RN2_t2 N2__t2 N2 667.28572049
RN2_t3 N2__t3 N2 356.362337093
RN2_t4 N2__t4 N2 374.421195754
RN2_t5 N2__t5 N2 225.570429521
RN2_t6 N2__t6 N2 198.053465004
CN2 N2 VSS 5.5687914e-14
RNA_t0 NA__t0 NA 177.9098074
RNA_t1 NA__t1 NA 299.987016677
RNA_t2 NA__t2 NA 782.211458547
RNA_t3 NA__t3 NA 91.0640100894
RNA_t4 NA__t4 NA 432.588253149
RNA_t5 NA__t5 NA 389.407654138
CNA NA VSS 7.726204e-14
RNB_t0 NB__t0 NB 875.385865849
RNB_t1 NB__t1 NB 134.537436555
RNB_t2 NB__t2 NB 66.6687788692
RNB_t3 NB__t3 NB 481.341493586
RNB_t4 NB__t4 NB 509.685725141
CNB NB VSS 4.7120272e-14
RNBG_t0 NBG__t0 NBG 319.655393327
RNBG_t1 NBG__t1 NBG 74.3376726087
RNBG_t2 NBG__t2 NBG 180.635494451
RNBG_t3 NBG__t3 NBG 497.957181646
RNBG_t4 NBG__t4 NBG 72.3456579667
CNBG NBG VSS 2.6929172e-14
RNC_t0 NC__t0 NC 58.0128241616
RNC_t1 NC__t1 NC 5.17314575229
RNC_t2 NC__t2 NC 12.3918471968
RNC_t3 NC__t3 NC 2.88062399517
RNC_t4 NC__t4 NC 11.6230131453
RNC_t5 NC__t5 NC 5.29674321447
RNC_t6 NC__t6 NC 8.50548296342
RNC_t7 NC__t7 NC 12.4439514887
RNC_t8 NC__t8 NC 8.42906808227
CNC NC VSS 1.06239997e-13
RND_t0 ND__t0 ND 229.124892636
RND_t1 ND__t1 ND 219.61306336
RND_t2 ND__t2 ND 685.527951368
RND_t3 ND__t3 ND 378.405592635
CND ND VSS 3.4731319e-14
RNR_t0 NR__t0 NR 356.720721034
RNR_t1 NR__t1 NR 764.350678615
RNR_t2 NR__t2 NR 286.922700175
RNR_t3 NR__t3 NR 286.922700175
CNR NR VSS 3.5361036e-14
RNT_t0 NT__t0 NT 330.085678635
RNT_t1 NT__t1 NT 330.085678635
RNT_t2 NT__t2 NT 330.085678635
RNT_t3 NT__t3 NT 330.085678635
RNT_t4 NT__t4 NT 97.5193258677
RNT_t5 NT__t5 NT 264.703412634
RNT_t6 NT__t6 NT 24.5247259175
RNT_t7 NT__t7 NT 71.0974037861
RNT_t8 NT__t8 NT 134.599552202
RNT_t9 NT__t9 NT 199.46944143
RNT_t10 NT__t10 NT 24.5247259175
RNT_t11 NT__t11 NT 24.5247259175
RNT_t12 NT__t12 NT 264.703412634
RNT_t13 NT__t13 NT 24.5247259175
RNT_t14 NT__t14 NT 71.0974037861
RNT_t15 NT__t15 NT 134.599552202
RNT_t16 NT__t16 NT 199.46944143
RNT_t17 NT__t17 NT 2593.74803582
CNT NT VSS 8.5988494e-14
RNZ_t0 NZ__t0 NZ 59.5605
RNZ_t1 NZ__t1 NZ 59.5605
CNZ NZ VSS 3.4541994e-14
RPB_t0 PB__t0 PB 1632.9207003
RPB_t1 PB__t1 PB 118.157609212
RPB_t2 PB__t2 PB 645.862714873
RPB_t3 PB__t3 PB 328.441785264
RPB_t4 PB__t4 PB 328.441785264
RPB_t5 PB__t5 PB 481.85070509
CPB PB VSS 4.7116177e-14
RPCAS_t0 PCAS__t0 PCAS 810.502975562
RPCAS_t1 PCAS__t1 PCAS 648.949250633
RPCAS_t2 PCAS__t2 PCAS 758.177517915
RPCAS_t3 PCAS__t3 PCAS 758.177517915
RPCAS_t4 PCAS__t4 PCAS 218.391841544
RPCAS_t5 PCAS__t5 PCAS 101.088066233
RPCAS_t6 PCAS__t6 PCAS 345.683006763
RPCAS_t7 PCAS__t7 PCAS 389.130532764
RPCAS_t8 PCAS__t8 PCAS 518.763990671
CPCAS PCAS VSS 5.3717376e-14
RPG_t0 PG__t0 PG 334.099181493
RPG_t1 PG__t1 PG 666.150692096
RPG_t2 PG__t2 PG 83.6375011211
RPG_t3 PG__t3 PG 629.340446714
RPG_t4 PG__t4 PG 731.227109932
RPG_t5 PG__t5 PG 417.439404629
RPG_t6 PG__t6 PG 151.271388757
RPG_t7 PG__t7 PG 234.368666133
RPG_t8 PG__t8 PG 318.177485975
RPG_t9 PG__t9 PG 599.142193276
RPG_t10 PG__t10 PG 430.615978181
RPG_t11 PG__t11 PG 514.848951694
CPG PG VSS 6.8097327e-14
RPTAT_t0 PTAT__t0 PTAT 160.800719866
RPTAT_t1 PTAT__t1 PTAT 375.388079927
RPTAT_t2 PTAT__t2 PTAT 213.257920424
RPTAT_t3 PTAT__t3 PTAT 221.189879783
CPTAT PTAT VSS 4.2434413e-14
RT0_t0 T0__t0 T0 320.043026094
RT0_t1 T0__t1 T0 313.559674231
RT0_t2 T0__t2 T0 312.817780188
RT0_t3 T0__t3 T0 320.719719486
CT0 T0 VSS 6.0943107e-14
RT1_t0 T1__t0 T1 309.075824733
RT1_t1 T1__t1 T1 305.716375402
RT1_t2 T1__t2 T1 315.094088938
RT1_t3 T1__t3 T1 299.558010926
CT1 T1 VSS 6.0274424e-14
RT2_t0 T2__t0 T2 296.459639641
RT2_t1 T2__t1 T2 299.620848801
RT2_t2 T2__t2 T2 286.687901974
RT2_t3 T2__t3 T2 308.985109584
CT2 T2 VSS 5.9605742e-14
RT3_t0 T3__t0 T3 280.061751539
RT3_t1 T3__t1 T3 297.643350284
RT3_t2 T3__t2 T3 301.967758756
RT3_t3 T3__t3 T3 274.39563942
CT3 T3 VSS 5.8937059e-14
RT4_t0 T4__t0 T4 292.687741783
RT4_t1 T4__t1 T4 256.490260142
RT4_t2 T4__t2 T4 303.654865819
RT4_t3 T4__t3 T4 263.556832256
CT4 T4 VSS 5.8268377e-14
RT5_t0 T5__t0 T5 311.783920291
RT5_t1 T5__t1 T5 160.212156364
RT5_t2 T5__t2 T5 151.573623345
CT5 T5 VSS 5.1212691e-14
RVDD_t0 VDD__t0 VDD 739.787329362
RVDD_t1 VDD__t1 VDD 764.699816758
RVDD_t2 VDD__t2 VDD 764.699816758
RVDD_t3 VDD__t3 VDD 352.066842898
RVDD_t4 VDD__t4 VDD 352.066842898
RVDD_t5 VDD__t5 VDD 352.066842898
RVDD_t6 VDD__t6 VDD 352.066842898
RVDD_t7 VDD__t7 VDD 286.184231085
RVDD_t8 VDD__t8 VDD 127.399093774
RVDD_t9 VDD__t9 VDD 127.399093774
RVDD_t10 VDD__t10 VDD 320.452608218
RVDD_t11 VDD__t11 VDD 320.452608218
RVDD_t12 VDD__t12 VDD 359.530019215
RVDD_t13 VDD__t13 VDD 359.530019215
RVDD_t14 VDD__t14 VDD 508.877745899
RVDD_t15 VDD__t15 VDD 508.877745899
RVDD_t16 VDD__t16 VDD 576.92811771
RVDD_t17 VDD__t17 VDD 576.92811771
RVDD_t18 VDD__t18 VDD 414.66400553
RVDD_t19 VDD__t19 VDD 414.66400553
RVDD_t20 VDD__t20 VDD 246.418709331
RVDD_t21 VDD__t21 VDD 246.418709331
RVDD_t22 VDD__t22 VDD 97.21837953
RVDD_t23 VDD__t23 VDD 40.7447657438
RVDD_t24 VDD__t24 VDD 153.824561687
RVDD_t25 VDD__t25 VDD 172.905409255
RVDD_t26 VDD__t26 VDD 229.541270357
RVDD_t27 VDD__t27 VDD 13.1048329979
RVDD_t28 VDD__t28 VDD 68.9446262762
RVDD_t29 VDD__t29 VDD 125.516100217
RVDD_t30 VDD__t30 VDD 314.507175097
RVDD_t31 VDD__t31 VDD 201.222077662
RVDD_t32 VDD__t32 VDD 257.862155666
RVDD_t33 VDD__t33 VDD 25.9443281711
RVDD_t34 VDD__t34 VDD 25.9443281711
RVDD_t35 VDD__t35 VDD 25.9443281711
RVDD_t36 VDD__t36 VDD 13.1048329979
RVDD_t37 VDD__t37 VDD 68.9446262762
RVDD_t38 VDD__t38 VDD 125.516100217
RVDD_t39 VDD__t39 VDD 314.507175097
RVDD_t40 VDD__t40 VDD 201.222077662
RVDD_t41 VDD__t41 VDD 257.862155666
RVDD_t42 VDD__t42 VDD 25.9443281711
CVDD VDD VSS 1.61974922e-13
RVSS_t0 VSS__t0 VSS 36.5363204952
RVSS_t1 VSS__t1 VSS 39.2222969318
RVSS_t2 VSS__t2 VSS 41.9115751444
RVSS_t3 VSS__t3 VSS 37.0191709143
RVSS_t4 VSS__t4 VSS 39.6724700071
RVSS_t5 VSS__t5 VSS 42.3331599451
RVSS_t6 VSS__t6 VSS 37.6913916993
RVSS_t7 VSS__t7 VSS 40.3004574355
RVSS_t8 VSS__t8 VSS 42.9222369406
RVSS_t9 VSS__t9 VSS 7.80361734452
RVSS_t10 VSS__t10 VSS 7.66128733675
RVSS_t11 VSS__t11 VSS 7.15729615731
RVSS_t12 VSS__t12 VSS 7.09762573854
RVSS_t13 VSS__t13 VSS 11.3919468504
RVSS_t14 VSS__t14 VSS 11.4138678251
RVSS_t15 VSS__t15 VSS 11.4652329168
RVSS_t16 VSS__t16 VSS 11.545649153
RVSS_t17 VSS__t17 VSS 11.6545151901
RVSS_t18 VSS__t18 VSS 11.7910430281
RVSS_t19 VSS__t19 VSS 11.9542849425
RVSS_t20 VSS__t20 VSS 12.1431636201
RVSS_t21 VSS__t21 VSS 12.3565034838
RVSS_t22 VSS__t22 VSS 12.5930613993
RVSS_t23 VSS__t23 VSS 13.763005714
RVSS_t24 VSS__t24 VSS 14.0240103462
RVSS_t25 VSS__t25 VSS 14.3038689703
RVSS_t26 VSS__t26 VSS 14.6014975352
RVSS_t27 VSS__t27 VSS 14.9158323416
RVSS_t28 VSS__t28 VSS 15.2458400896
RVSS_t29 VSS__t29 VSS 15.5905255542
RVSS_t30 VSS__t30 VSS 15.9489371275
RVSS_t31 VSS__t31 VSS 16.3201705064
RVSS_t32 VSS__t32 VSS 16.7033708167
RVSS_t33 VSS__t33 VSS 17.0977334564
RVSS_t34 VSS__t34 VSS 17.5025039201
RVSS_t35 VSS__t35 VSS 17.9169768383
RVSS_t36 VSS__t36 VSS 18.3404944316
RVSS_t37 VSS__t37 VSS 18.7724445502
RVSS_t38 VSS__t38 VSS 19.2122584359
RVSS_t39 VSS__t39 VSS 19.6594083188
RVSS_t40 VSS__t40 VSS 20.1134049357
RVSS_t41 VSS__t41 VSS 20.5737950362
RVSS_t42 VSS__t42 VSS 21.0401589275
RVSS_t43 VSS__t43 VSS 21.5121080934
RVSS_t44 VSS__t44 VSS 21.9892829117
RVSS_t45 VSS__t45 VSS 22.4713504878
RVSS_t46 VSS__t46 VSS 22.9580026121
RVSS_t47 VSS__t47 VSS 23.6735572522
RVSS_t48 VSS__t48 VSS 24.1639427042
RVSS_t49 VSS__t49 VSS 22.2742268278
RVSS_t50 VSS__t50 VSS 22.8243404649
RVSS_t51 VSS__t51 VSS 22.6661782276
RVSS_t52 VSS__t52 VSS 23.2360817517
RVSS_t53 VSS__t53 VSS 23.5844169099
RVSS_t54 VSS__t54 VSS 24.160610579
RVSS_t55 VSS__t55 VSS 24.6598771817
RVSS_t56 VSS__t56 VSS 25.2382734756
RVSS_t57 VSS__t57 VSS 25.7869813343
RVSS_t58 VSS__t58 VSS 26.3662631898
RVSS_t59 VSS__t59 VSS 53.1842664684
RVSS_t60 VSS__t60 VSS 51.2709872655
RVSS_t61 VSS__t61 VSS 49.3610755925
RVSS_t62 VSS__t62 VSS 47.4549380486
RVSS_t63 VSS__t63 VSS 45.5530484141
RVSS_t64 VSS__t64 VSS 43.6559618782
RVSS_t65 VSS__t65 VSS 29.5043770479
RVSS_t66 VSS__t66 VSS 27.0007057354
RVSS_t67 VSS__t67 VSS 25.3626092366
RVSS_t68 VSS__t68 VSS 23.5933572026
RVSS_t69 VSS__t69 VSS 26.3289624881
RVSS_t70 VSS__t70 VSS 25.8695541719
RVSS_t71 VSS__t71 VSS 16.0665599544
RVSS_t72 VSS__t72 VSS 20.7345291374
RVSS_t73 VSS__t73 VSS 18.598332415
RVSS_t74 VSS__t74 VSS 16.5566009468
RVSS_t75 VSS__t75 VSS 18.1476676088
RVSS_t76 VSS__t76 VSS 15.227093608
RVSS_t77 VSS__t77 VSS 14.801636684
RVSS_t78 VSS__t78 VSS 14.4601010067
RVSS_t79 VSS__t79 VSS 14.0627397112
RVSS_t80 VSS__t80 VSS 16.0788157762
RVSS_t81 VSS__t81 VSS 15.8156384103
RVSS_t82 VSS__t82 VSS 15.5643090512
RVSS_t83 VSS__t83 VSS 15.3254106148
RVSS_t84 VSS__t84 VSS 15.0995331432
RVSS_t85 VSS__t85 VSS 14.8872693309
RVSS_t86 VSS__t86 VSS 53.1842664684
RVSS_t87 VSS__t87 VSS 53.1842664684
RVSS_t88 VSS__t88 VSS 53.1842664684
RVSS_t89 VSS__t89 VSS 29.5043770479
RVSS_t90 VSS__t90 VSS 27.0007057354
RVSS_t91 VSS__t91 VSS 18.1476676088
RVSS_t92 VSS__t92 VSS 25.8695541719
RVSS_t93 VSS__t93 VSS 20.7345291374
RVSS_t94 VSS__t94 VSS 18.598332415
RVSS_t95 VSS__t95 VSS 15.227093608
RVSS_t96 VSS__t96 VSS 14.4601010067
RVSS_t97 VSS__t97 VSS 36.5363204952
RVSS_t98 VSS__t98 VSS 41.9115751444
RVSS_t99 VSS__t99 VSS 37.0191709143
RVSS_t100 VSS__t100 VSS 39.6724700071
RVSS_t101 VSS__t101 VSS 42.3331599451
RVSS_t102 VSS__t102 VSS 37.6913916993
RVSS_t103 VSS__t103 VSS 40.3004574355
RVSS_t104 VSS__t104 VSS 42.9222369406
RVSS_t105 VSS__t105 VSS 39.2222969318
RVSS_t106 VSS__t106 VSS 26.3662631898
RVSS_t107 VSS__t107 VSS 14.0627397112
RVSS_t108 VSS__t108 VSS 14.801636684
RVSS_t109 VSS__t109 VSS 16.5566009468
RVSS_t110 VSS__t110 VSS 16.0665599544
RVSS_t111 VSS__t111 VSS 23.5933572026
RVSS_t112 VSS__t112 VSS 25.3626092366
RVSS_t113 VSS__t113 VSS 43.6559618782
RVSS_t114 VSS__t114 VSS 43.6559618782
RVSS_t115 VSS__t115 VSS 49.3610755925
RVSS_t116 VSS__t116 VSS 47.4549380486
RVSS_t117 VSS__t117 VSS 45.5530484141
RVSS_t118 VSS__t118 VSS 43.6559618782
RVSS_t119 VSS__t119 VSS 51.2709872655
RVSS_t120 VSS__t120 VSS 15.3254106148
RVSS_t121 VSS__t121 VSS 15.8156384103
RVSS_t122 VSS__t122 VSS 15.5643090512
RVSS_t123 VSS__t123 VSS 15.3254106148
RVSS_t124 VSS__t124 VSS 15.0995331432
RVSS_t125 VSS__t125 VSS 14.8872693309
CVSS VSS VSS 2.09783916e-13
Ccc_CTAT_NA CTAT NA 8.311e-18
Ccc_CTAT_NB CTAT NB 8.311e-18
Ccc_CTAT_NC CTAT NC 8.311e-18
Ccc_CTAT_NT CTAT NT 8.311e-18
Ccc_CTAT_NZ CTAT NZ 8.311e-18
Ccc_CTAT_PTAT CTAT PTAT 8.311e-18
Ccc_CTAT_T0 CTAT T0 8.311e-18
Ccc_CTAT_T1 CTAT T1 8.311e-18
Ccc_CTAT_T2 CTAT T2 8.311e-18
Ccc_CTAT_T3 CTAT T3 8.311e-18
Ccc_CTAT_T4 CTAT T4 8.311e-18
Ccc_CTAT_T5 CTAT T5 8.311e-18
Ccc_CTAT_VDD CTAT VDD 7.4799e-17
Ccc_EN_VDD EN VDD 7.4799e-17
Ccc_ENB_VDD ENB VDD 7.4799e-17
Ccc_IBIAS_VDD IBIAS VDD 2.4933e-17
Ccc_M1D_NT M1D NT 8.311e-18
Ccc_M1D_VDD M1D VDD 1.6622e-17
Ccc_M2D_NT M2D NT 8.311e-18
Ccc_M2D_VDD M2D VDD 1.6622e-17
Ccc_M3D_NT M3D NT 8.311e-18
Ccc_M3D_VDD M3D VDD 1.6622e-17
Ccc_N1_NT N1 NT 8.311e-18
Ccc_N1_VDD N1 VDD 8.311e-18
Ccc_N2_NA N2 NA 8.311e-18
Ccc_N2_NB N2 NB 8.311e-18
Ccc_N2_NC N2 NC 8.311e-18
Ccc_N2_NT N2 NT 8.311e-18
Ccc_N2_PTAT N2 PTAT 8.311e-18
Ccc_N2_T0 N2 T0 8.311e-18
Ccc_N2_T1 N2 T1 8.311e-18
Ccc_N2_T2 N2 T2 8.311e-18
Ccc_N2_T3 N2 T3 8.311e-18
Ccc_N2_T4 N2 T4 8.311e-18
Ccc_N2_T5 N2 T5 8.311e-18
Ccc_N2_VDD N2 VDD 7.4799e-17
Ccc_NA_NC NA NC 1.6622e-17
Ccc_NA_NT NA NT 8.311e-18
Ccc_NA_NZ NA NZ 8.311e-18
Ccc_NA_PTAT NA PTAT 8.311e-18
Ccc_NA_T0 NA T0 8.311e-18
Ccc_NA_T1 NA T1 8.311e-18
Ccc_NA_T2 NA T2 8.311e-18
Ccc_NA_T3 NA T3 8.311e-18
Ccc_NA_T4 NA T4 8.311e-18
Ccc_NA_T5 NA T5 8.311e-18
Ccc_NA_VDD NA VDD 7.4799e-17
Ccc_NA_VSS NA VSS 1.32976e-16
Ccc_NB_NC NB NC 8.311e-18
Ccc_NB_NT NB NT 8.311e-18
Ccc_NB_NZ NB NZ 8.311e-18
Ccc_NB_PTAT NB PTAT 8.311e-18
Ccc_NB_T0 NB T0 8.311e-18
Ccc_NB_T1 NB T1 8.311e-18
Ccc_NB_T2 NB T2 8.311e-18
Ccc_NB_T3 NB T3 8.311e-18
Ccc_NB_T4 NB T4 8.311e-18
Ccc_NB_T5 NB T5 8.311e-18
Ccc_NB_VDD NB VDD 7.4799e-17
Ccc_NBG_VDD NBG VDD 3.3244e-17
Ccc_NC_NT NC NT 8.311e-18
Ccc_NC_NZ NC NZ 8.311e-18
Ccc_NC_PTAT NC PTAT 8.311e-18
Ccc_NC_T0 NC T0 1.6622e-17
Ccc_NC_T1 NC T1 1.6622e-17
Ccc_NC_T2 NC T2 1.6622e-17
Ccc_NC_T3 NC T3 1.6622e-17
Ccc_NC_T4 NC T4 1.6622e-17
Ccc_NC_T5 NC T5 1.6622e-17
Ccc_NC_VDD NC VDD 7.4799e-17
Ccc_NC_VSS NC VSS 2.65952e-16
Ccc_ND_NT ND NT 8.311e-18
Ccc_ND_VDD ND VDD 6.6488e-17
Ccc_NR_NT NR NT 8.311e-18
Ccc_NR_VDD NR VDD 6.6488e-17
Ccc_NT_NZ NT NZ 8.311e-18
Ccc_NT_PG NT PG 8.311e-18
Ccc_NT_PTAT NT PTAT 8.311e-18
Ccc_NT_T0 NT T0 8.311e-18
Ccc_NT_T1 NT T1 8.311e-18
Ccc_NT_T2 NT T2 8.311e-18
Ccc_NT_T3 NT T3 8.311e-18
Ccc_NT_T4 NT T4 8.311e-18
Ccc_NT_T5 NT T5 8.311e-18
Ccc_NT_VDD NT VDD 7.4799e-17
Ccc_NZ_PG NZ PG 1.36745e-16
Ccc_NZ_VDD NZ VDD 7.4799e-17
Ccc_PB_VDD PB VDD 5.8177e-17
Ccc_PCAS_VDD PCAS VDD 4.1555e-17
Ccc_PG_VDD PG VDD 7.4799e-17
Ccc_PTAT_T0 PTAT T0 8.311e-18
Ccc_PTAT_T1 PTAT T1 8.311e-18
Ccc_PTAT_T2 PTAT T2 8.311e-18
Ccc_PTAT_T3 PTAT T3 8.311e-18
Ccc_PTAT_T4 PTAT T4 8.311e-18
Ccc_PTAT_T5 PTAT T5 8.311e-18
Ccc_PTAT_VDD PTAT VDD 7.4799e-17
Ccc_T0_T1 T0 T1 1.6622e-17
Ccc_T0_T2 T0 T2 1.6622e-17
Ccc_T0_T3 T0 T3 1.6622e-17
Ccc_T0_T4 T0 T4 1.6622e-17
Ccc_T0_T5 T0 T5 1.6622e-17
Ccc_T0_VDD T0 VDD 7.4799e-17
Ccc_T1_T2 T1 T2 1.6622e-17
Ccc_T1_T3 T1 T3 1.6622e-17
Ccc_T1_T4 T1 T4 1.6622e-17
Ccc_T1_T5 T1 T5 1.6622e-17
Ccc_T1_VDD T1 VDD 7.4799e-17
Ccc_T2_T3 T2 T3 1.6622e-17
Ccc_T2_T4 T2 T4 1.6622e-17
Ccc_T2_T5 T2 T5 1.6622e-17
Ccc_T2_VDD T2 VDD 7.4799e-17
Ccc_T3_T4 T3 T4 1.6622e-17
Ccc_T3_T5 T3 T5 1.6622e-17
Ccc_T3_VDD T3 VDD 7.4799e-17
Ccc_T4_T5 T4 T5 1.6622e-17
Ccc_T4_VDD T4 VDD 7.4799e-17
Ccc_T5_VDD T5 VDD 7.4799e-17
Rvsubs_dctie VSS 0 1e+12
.ends temp_core
