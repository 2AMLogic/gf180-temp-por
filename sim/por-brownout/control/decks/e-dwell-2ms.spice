* por-brownout root-cause control @ tt / 27.0 C / 3.3 V -- GENERATED by run_dip_rootcause.py, do not edit
* pdk=gf180mcuD@c6d73a35f524070e85faff4a6a9eef49553ebc2b  harness=0.1.0

.param vdd_nom=3.3
.param vdd_val=3.3
.param temp_c=27.0

.include "/Users/rwalters/.volare/gf180mcuD/libs.tech/ngspice/design.ngspice"
.lib "/Users/rwalters/.volare/gf180mcuD/libs.tech/ngspice/sm141064.ngspice" typical
.lib "/Users/rwalters/.volare/gf180mcuD/libs.tech/ngspice/sm141064.ngspice" res_typical
.lib "/Users/rwalters/.volare/gf180mcuD/libs.tech/ngspice/sm141064.ngspice" bjt_typical
.lib "/Users/rwalters/.volare/gf180mcuD/libs.tech/ngspice/sm141064.ngspice" diode_typical
.lib "/Users/rwalters/.volare/gf180mcuD/libs.tech/ngspice/sm141064.ngspice" moscap_typical
.lib "/Users/rwalters/.volare/gf180mcuD/libs.tech/ngspice/sm141064.ngspice" mimcap_typical

.temp 27.0
.options reltol=1e-4
.options abstol=1e-13
.options vntol=1e-8
.options method=gear

.param t_dip=20.0m
.param t_edge=0.001m
.param t_dwell=2.0m
.param dip_v=1.0

.include "../dip_shape.spice"
.include "../../../../design/netlist/temp_por_top.spice"

.control
set numdgt=8
set noaskquit
tran 20u 23.002m
let praw_r = v(xdut.por_raw)/(v(vdd)+0.001)
let rst_r = v(resetn)/(v(vdd)+0.001)
let bok_r = v(xdut.bias_ok)/(v(vdd)+0.001)
meas tran t_vpor when v(vdd)=2.39 fall=1 td=20.0m
meas tran t_vddlo when v(vdd)=2.22 fall=1 td=20.0m
meas tran t_vddhi when v(vdd)=2.22 rise=1 td=20.0m
meas tran vref_pre find v(xdut.vref) at=19.9m
meas tran pg_pre find v(xdut.xbias.pg) at=19.9m
meas tran vdd_pre find v(vdd) at=19.9m
meas tran vref_at_vpor find v(xdut.vref) when v(vdd)=2.39 fall=1 td=20.0m
meas tran sns_at_vpor find v(xdut.xcmp.sns) when v(vdd)=2.39 fall=1 td=20.0m
meas tran pg_at_vpor find v(xdut.xbias.pg) when v(vdd)=2.39 fall=1 td=20.0m
meas tran vref_p8 find v(xdut.vref) at=20.008m
meas tran vdd_p8 find v(vdd) at=20.008m
meas tran pg_p8 find v(xdut.xbias.pg) at=20.008m
meas tran praw_r_min min praw_r from=20.0m to=22.001m
meas tran t_praw when praw_r=0.5 fall=1 td=20.0m
meas tran vdd_at_praw find v(vdd) when praw_r=0.5 fall=1 td=20.0m
meas tran biasok_r_min min bok_r from=20.0m to=22.001m
meas tran rst_r_min min rst_r from=20.0m to=22.001m
meas tran rst_min min v(resetn) from=20.0m to=22.001m
meas tran t_rst when rst_r=0.1 fall=1 td=20.0m
meas tran vdd_at_rst find v(vdd) when rst_r=0.1 fall=1 td=20.0m
.endc
.end
