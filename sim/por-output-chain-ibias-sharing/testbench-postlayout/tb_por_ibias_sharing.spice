* tb_por_ibias_sharing -- GENERATED by sim/build_tb.py
* Do not edit. Sources:
*   sim/por-output-chain-ibias-sharing/testbench/stimulus.spice
*   layout/postlayout/bias_core.spice  (sha256 f5c856ebe1b7669e1fbadfe8dce6b75a1f376838a32d6551cdf6e9055067906c)
*   layout/postlayout/temp_core.spice  (sha256 8cb8c70e3a8ba31fdc73653eea505f0868e2da40cc9bb0a7ed7bf45c80eb6059)
*   layout/postlayout/por_comparator.spice  (sha256 7f18f5adb295c1be56e6edfd1af6ad355c538bb78a4a2f56efe4aa786d864299)
*   layout/postlayout/por_output_chain.spice  (sha256 3d6e84ccb08651c7d07e9b343a937b64b2395f0860b677fdb88eb017a062f3a5)
* Regenerate with:
*   python3 sim/build_tb.py

* por-output-chain-ibias-sharing -- stimulus half of the testbench fragment.
*
* The other half is a verbatim copy of design/netlist/bias_core.spice,
* design/netlist/temp_core.spice, design/netlist/por_comparator.spice and
* design/netlist/por_output_chain.spice, appended by sim/build_tb.py to
* produce tb_por_ibias_sharing.spice. Edit THIS file (or the schematics),
* never the generated fragment.
*
* Netlist FRAGMENT: no .include / .lib / .temp / .control / .end -- the
* harness owns those. Parameters it supplies: vdd_val, vdd_nom, temp_c.
*
* WHY THIS EXPERIMENT EXISTS (issue #221)
*
* IBIAS is one shared net (DR-010): bias_core sources into it and temp_core,
* por_comparator and por_output_chain each hang their own mirror-input diode
* off it, so the source current splits. design/por_output_chain.md ("Hand-
* off to #11: the IBIAS envelope is the real constraint") derives that this
* cell's own deglitch dwell must not see IBIAS fall below about 0.44x
* nominal (500 nA nominal, so ~220 nA) at the SS/-40C corner, or the
* <=10us por-brownout ceiling is at risk. Nothing committed measures what
* current por_output_chain actually receives on the real assembly:
* sim/bias-core-ibias-sharing/ answers the *liveness* question (does the
* shared node survive a disabled temp_core, DR-010) but never instantiates
* por_output_chain and only reports the shared node's VOLTAGE, not any
* individual consumer's share of the current. This experiment closes that
* gap: it is a MAGNITUDE record, not a liveness one.
*
* Two branches, identical rail, differing only in temp_core's EN -- the
* same asserted/released distinction sim/bias-core-ibias-sharing/ already
* uses, extended to instantiate por_output_chain and to meter every
* consumer leg individually rather than only the shared node's voltage:
*
*   A. RESETn asserted: EN = 0. temp_core is high-Z per DR-010 (its XMBD's
*      gate is pinned to VSS through XMDNB once disabled, so it no longer
*      clamps the node -- the clamp DR-010 removed drew the whole
*      reference; the high-Z contract draws <=0.152 nA instead).
*   B. RESETn released: EN = 1. temp_core's own XMBD mirror diode rejoins
*      the shared node -- design/bias_core.md's "The shared IBIAS net"
*      measures the node stepping DOWN at release (temp_core's mirror
*      diode is a fourth load on a source that does not grow), which is
*      why released is expected to be the tighter of the two states.
*
* Neither branch closes the startup loop through por_output_chain's own
* RESETn output driving temp_core's EN pin back around (that closed-loop
* dynamic is sim/temp-por-top-release/'s job, and DR-016's XMRLK release
* latch already root-causes its transient behaviour). EN is DC-forced
* exactly as sim/bias-core-ibias-sharing/ already does, so this experiment
* isolates the STEADY-STATE current split at each state rather than the
* transient that connects them.
*
* Each leg gets its own zero-volt ammeter in series with the cell's IBIAS
* pin, all four tied to the same electrical node per branch (an ideal 0 V
* source adds no impedance), using the SAME sign convention
* sim/bias-core-ibias-sharing/ established: positive current means "flows
* from the shared node into this device" -- bias_core's own ammeter reads
* the total current it sources, and each consumer's ammeter reads what it
* draws from the shared node.
*
* The rail is ramped (not DC-stepped) so both branches start from a real
* cold start, exactly as sim/bias-core-ibias-sharing/ does; measurements are
* taken well after settling.

* ---- A. RESETn asserted (temp_core disabled) -------------------------
vsupa    vdda 0 PWL(0 0 100u {vdd_val} 1 {vdd_val})
vena     ena  0 dc 0
vibcorea nbcorea sharea dc 0
vibtmpa  sharea nibtmpa dc 0
vibcmpa  sharea nibcmpa dc 0
vibpora  sharea nibpora dc 0
xbiasa vdda 0 nbcorea vrefa oka          bias_core
xtempa vdda 0 nibtmpa ena ptata ctata    temp_core
xcmpa  vdda 0 nibcmpa vrefa oka por_rawa por_comparator
xpora  vdda 0 nibpora por_rawa resetna   por_output_chain
Rpta ptata 0 1T
Rcta ctata 0 1T

* ---- B. RESETn released (temp_core enabled) ---------------------------
vsupb    vddb 0 PWL(0 0 100u {vdd_val} 1 {vdd_val})
venb     enb  vddb dc 0
vibcoreb nbcoreb shareb dc 0
vibtmpb  shareb nibtmpb dc 0
vibcmpb  shareb nibcmpb dc 0
vibporb  shareb nibporb dc 0
xbiasb vddb 0 nbcoreb vrefb okb          bias_core
xtempb vddb 0 nibtmpb enb ptatb ctatb    temp_core
xcmpb  vddb 0 nibcmpb vrefb okb por_rawb por_comparator
xporb  vddb 0 nibporb por_rawb resetnb   por_output_chain
Rptb ptatb 0 1T
Rctb ctatb 0 1T

* bias_core -- post-layout netlist
* GENERATED by layout/postlayout.py -- do not edit.
*
* FROM THE LAYOUT: every device and its dimensions, the whole
*   topology, and first-order interconnect R/C on 47/47 nets
*   (sigma 1961.6 fF, of which 0.585 fF is net-to-net coupling).
*   One star per net: <net> is the hub, <net>__t<k> each device
*   terminal on it, R<net>_t<k> the arm between them.
*   klt 0.6.0, deck gf180mcu,
*   GDS sha256 443ed6629512ed08...
* Net names are the schematic's, restored through klt lvs's own net
*   correspondence -- match, 47/47 nets, every one paired.
*
* NOT FROM THE LAYOUT -- see layout/postlayout/AUDIT.md:
*   3 body/plate net(s) tied to the net the schematic puts
*   them on. The extraction deck's connectivity stack does not reach
*   an Nwell, a substrate ring, a bipolar base well or a MiM plate,
*   so they extract isolated and would otherwise float.
*   No ideal device: every golden device is drawn.
*
.subckt bias_core VDD VSS IBIAS VREF BIAS_OK

* --- drawn devices ---
X1 VDD__t11 VDD__t10 KS1__t2 VSS__t57 nfet_03v3 L=8u W=1u nf=1 ad=0.8p as=0.8p pd=3.6u ps=3.6u m=1
X2 KS1__t1 KS1__t0 KS2__t2 VSS__t58 nfet_03v3 L=8u W=1u nf=1 ad=0.8p as=0.8p pd=3.6u ps=3.6u m=1
X3 KS2__t1 KS2__t0 KS3__t2 VSS__t59 nfet_03v3 L=8u W=1u nf=1 ad=0.8p as=0.8p pd=3.6u ps=3.6u m=1
X4 KS3__t1 KS3__t0 KS4__t0 VSS__t60 nfet_03v3 L=8u W=1u nf=1 ad=0.8p as=0.8p pd=3.6u ps=3.6u m=1
X5 KS4__t1 KS4__t2 NKG__t3 VSS__t61 nfet_03v3 L=8u W=1u nf=1 ad=0.8p as=0.8p pd=3.6u ps=3.6u m=1
X6 PG__t3 NKG__t1 VSS__t4 VSS__t62 nfet_03v3 L=4u W=1u nf=1 ad=0.8p as=0.8p pd=3.6u ps=3.6u m=1
X7 NBG__t3 NBG__t1 VSS__t0 VSS__t63 nfet_03v3 L=4u W=2u nf=1 ad=1.6p as=1.6p pd=5.6u ps=5.6u m=1
X8 PB__t2 NBG__t2 VSS__t18 VSS__t64 nfet_03v3 L=4u W=2u nf=1 ad=1.6p as=1.6p pd=5.6u ps=5.6u m=1
X9 NKM__t3 NKM__t2 VSS__t19 VSS__t65 nfet_03v3 L=4u W=2u nf=1 ad=1.6p as=1.6p pd=5.6u ps=5.6u m=1
X10 NOKL__t2 NOKL__t0 VSS__t20 VSS__t66 nfet_03v3 L=4u W=2u nf=1 ad=1.6p as=1.6p pd=5.6u ps=5.6u m=1
X11 NOKO__t2 NOKL__t1 VSS__t22 VSS__t67 nfet_03v3 L=4u W=2u nf=1 ad=1.6p as=1.6p pd=5.6u ps=5.6u m=1
X12 NOKO__t0 NKG__t2 VSS__t5 VSS__t69 nfet_03v3 L=1u W=2u nf=1 ad=1.6p as=1.6p pd=5.6u ps=5.6u m=1
X13 NOKX__t2 NOKO__t1 VSS__t21 VSS__t68 nfet_03v3 L=4u W=2u nf=1 ad=1.6p as=1.6p pd=5.6u ps=5.6u m=1
X14 N1__t1 N1__t2 VSS__t1 VSS__t70 nfet_03v3 L=8u W=4u nf=1 ad=3.2p as=3.2p pd=9.6u ps=9.6u m=1
X15 N2__t2 N1__t3 VSS__t17 VSS__t71 nfet_03v3 L=8u W=4u nf=1 ad=3.2p as=3.2p pd=9.6u ps=9.6u m=1
X16 BIAS_OK__t0 NOKX__t0 VSS__t6 VSS__t72 nfet_03v3 L=0.5u W=4u nf=1 ad=3.2p as=3.2p pd=9.6u ps=9.6u m=1
X17 PG__t2 N2__t0 VSS__t2 VSS__t73 nfet_03v3 L=8u W=8u nf=1 ad=6.4p as=6.4p pd=17.6u ps=17.6u m=1
X18 NKG__t0 NKM__t1 VSS__t3 VSS__t74 nfet_03v3 L=4u W=8u nf=1 ad=6.4p as=6.4p pd=17.6u ps=17.6u m=1
X19 NKM__t0 PB__t1 VDD__t7 VDD__t8 pfet_03v3 L=4u W=1u nf=1 ad=0.8p as=0.8p pd=3.6u ps=3.6u m=1
X20 TOK__t0 PB__t4 VDD__t17 VDD__t14 pfet_03v3 L=4u W=1u nf=1 ad=0.8p as=0.8p pd=3.6u ps=3.6u m=1
X21 NOKX__t3 PB__t3 VDD__t15 VDD__t12 pfet_03v3 L=4u W=1u nf=1 ad=0.8p as=0.8p pd=3.6u ps=3.6u m=1
X22 BIAS_OK__t1 NOKX__t4 VDD__t16 VDD__t13 pfet_03v3 L=4u W=1u nf=1 ad=0.8p as=0.8p pd=3.6u ps=3.6u m=1
X23 NBG__t0 PG__t1 VDD__t2 VDD__t3 pfet_03v3 L=4u W=2u nf=1 ad=1.6p as=1.6p pd=5.6u ps=5.6u m=1
X24 PB__t5 PB__t8 VDD__t24 VDD__t21 pfet_03v3 L=4u W=2u nf=1 ad=1.6p as=1.6p pd=5.6u ps=5.6u m=1
X25 NT__t2 PB__t7 VDD__t23 VDD__t20 pfet_03v3 L=4u W=2u nf=1 ad=1.6p as=1.6p pd=5.6u ps=5.6u m=1
X26 PG__t5 PB__t6 VDD__t22 VDD__t19 pfet_03v3 L=4u W=2u nf=1 ad=1.6p as=1.6p pd=5.6u ps=5.6u m=1
X27 NA__t0 PG__t0 VDD__t0 VDD__t1 pfet_03v3 L=4u W=8u nf=1 ad=6.4p as=6.4p pd=17.6u ps=17.6u m=1
X28 NBTOP__t1 PG__t7 VDD__t30 VDD__t28 pfet_03v3 L=4u W=8u nf=1 ad=6.4p as=6.4p pd=17.6u ps=17.6u m=1
X29 VREF__t1 PG__t6 VDD__t29 VDD__t27 pfet_03v3 L=4u W=8u nf=1 ad=6.4p as=6.4p pd=17.6u ps=17.6u m=1
X30 NOKO__t3 NA__t3 TOK__t2 VDD__t26 pfet_03v3 L=4u W=8u nf=1 ad=6.4p as=6.4p pd=17.6u ps=17.6u m=1
X31 NOKL__t3 NBTOP__t2 TOK__t1 VDD__t25 pfet_03v3 L=4u W=8u nf=1 ad=6.4p as=6.4p pd=17.6u ps=17.6u m=1
X32 N1__t0 NA__t1 NT__t0 VDD__t6 pfet_03v3 L=4u W=16u nf=1 ad=12.8p as=12.8p pd=33.6u ps=33.6u m=1
X33 N2__t3 NB__t2 NT__t1 VDD__t18 pfet_03v3 L=4u W=16u nf=1 ad=12.8p as=12.8p pd=33.6u ps=33.6u m=1
X34 IBIAS__t0 PB__t0 VDD__t4 VDD__t5 pfet_03v3 L=4u W=40u nf=1 ad=32p as=32p pd=81.6u ps=81.6u m=1
X35 VSS__t23 VSS__t9 EC__t2 pnp_10p00x10p00
X36 VSS__t24 VSS__t13 EC__t5 pnp_10p00x10p00
X37 VSS__t25 VSS__t10 EC__t3 pnp_10p00x10p00
X38 VSS__t26 VSS__t11 EC__t4 pnp_10p00x10p00
X39 VSS__t27 VSS__t12 NA__t2 pnp_10p00x10p00
X40 VSS__t28 VSS__t8 EC__t1 pnp_10p00x10p00
X41 VSS__t29 VSS__t16 ER__t1 pnp_10p00x10p00
X42 VSS__t30 VSS__t7 EC__t8 pnp_10p00x10p00
X43 VSS__t31 VSS__t15 EC__t7 pnp_10p00x10p00
X44 VSS__t32 VSS__t14 EC__t6 pnp_10p00x10p00
X45 VDD__t9 NOKX__t1 cap_mim_2f0_m3m4_noshield c_width=6u c_length=6u
X46 PG__t4 NZ__t0 cap_mim_2f0_m3m4_noshield c_width=20u c_length=20u
X47 VREF__t0 XR2__1__t0 VSS__t33 ppolyf_u_3k r_width=2u r_length=256.5u
X48 XR2__2__t0 XR2__1__t1 VSS__t34 ppolyf_u_3k r_width=2u r_length=256.5u
X49 XR2__2__t1 XR2__3__t1 VSS__t41 ppolyf_u_3k r_width=2u r_length=256.5u
X50 XR2__4__t1 XR2__3__t0 VSS__t35 ppolyf_u_3k r_width=2u r_length=256.5u
X51 XR2__4__t0 XR2__5__t0 VSS__t42 ppolyf_u_3k r_width=2u r_length=256.5u
X52 XR2__6__t1 XR2__5__t1 VSS__t36 ppolyf_u_3k r_width=2u r_length=256.5u
X53 XR2__6__t0 XR2__7__t0 VSS__t43 ppolyf_u_3k r_width=2u r_length=256.5u
X54 XR2__8__t1 XR2__7__t1 VSS__t37 ppolyf_u_3k r_width=2u r_length=256.5u
X55 XR2__8__t0 XR2__9__t0 VSS__t44 ppolyf_u_3k r_width=2u r_length=256.5u
X56 XR2__10__t1 XR2__9__t1 VSS__t38 ppolyf_u_3k r_width=2u r_length=256.5u
X57 XR2__10__t0 XR2__11__t0 VSS__t45 ppolyf_u_3k r_width=2u r_length=256.5u
X58 XR2__12__t1 XR2__11__t1 VSS__t39 ppolyf_u_3k r_width=2u r_length=256.5u
X59 XR2__12__t0 XR2__13__t0 VSS__t46 ppolyf_u_3k r_width=2u r_length=256.5u
X60 XR2__14__t1 XR2__13__t1 VSS__t40 ppolyf_u_3k r_width=2u r_length=256.5u
X61 XR2__14__t0 XR2__15__t0 VSS__t47 ppolyf_u_3k r_width=2u r_length=256.5u
X62 ER__t0 XR2__15__t1 VSS__t48 ppolyf_u_3k r_width=2u r_length=256.5u
X63 NZ__t1 XRZ__1__t0 VSS__t49 ppolyf_u_3k r_width=2u r_length=254u
X64 XRZ__2__t0 XRZ__1__t1 VSS__t50 ppolyf_u_3k r_width=2u r_length=254u
X65 XRZ__2__t1 XRZ__3__t0 VSS__t51 ppolyf_u_3k r_width=2u r_length=254u
X66 N2__t1 XRZ__3__t1 VSS__t52 ppolyf_u_3k r_width=2u r_length=254u
X67 NB__t0 XR1__1__t0 VSS__t53 ppolyf_u_3k r_width=2u r_length=175u
X68 EC__t0 XR1__1__t1 VSS__t54 ppolyf_u_3k r_width=2u r_length=175u
X69 NBTOP__t0 XRT__1__t0 VSS__t55 ppolyf_u_3k r_width=2u r_length=8.75u
X70 NB__t1 XRT__1__t1 VSS__t56 ppolyf_u_3k r_width=2u r_length=8.75u

R_10_t0 NT__t0 NT 627.59414468
R_10_t1 NT__t1 NT 1882.86781906
R_10_t2 NT__t2 NT 2174.12383626
C_10 NT VSS 4.9951788e-14
R_11_t0 N1__t0 N1 2483.75464397
R_11_t1 N1__t1 N1 686.286100229
R_11_t2 N1__t2 N1 686.286100229
R_11_t3 N1__t3 N1 1111.53145557
C_11 N1 VSS 5.978126e-14
R_12_t0 N2__t0 N2 827.153205074
R_12_t1 N2__t1 N2 3874.61260019
R_12_t2 N2__t2 N2 979.748226084
R_12_t3 N2__t3 N2 2173.53656866
C_12 N2 VSS 8.4773094e-14
R_13_t0 NKM__t0 NKM 2437.59006439
R_13_t1 NKM__t1 NKM 913.50607551
R_13_t2 NKM__t2 NKM 762.895630051
R_13_t3 NKM__t3 NKM 762.895630051
C_13 NKM VSS 5.7923066e-14
R_14_t0 TOK__t0 TOK 2208.25155211
R_14_t1 TOK__t1 TOK 2114.24861265
R_14_t2 TOK__t2 TOK 368.025235243
C_14 TOK VSS 5.2350545e-14
R_15_t0 NOKO__t0 NOKO 798.735608557
R_15_t1 NOKO__t1 NOKO 900.604258303
R_15_t2 NOKO__t2 NOKO 696.871607469
R_15_t3 NOKO__t3 NOKO 2396.20682567
C_15 NOKO VSS 5.9161863e-14
R_16_t0 NOKL__t0 NOKL 764.207687226
R_16_t1 NOKL__t1 NOKL 913.585012659
R_16_t2 NOKL__t2 NOKL 764.207687226
R_16_t3 NOKL__t3 NOKL 2441.99661289
C_16 NOKL VSS 6.0794305e-14
R_17_t0 NOKX__t0 NOKX 648.721578834
R_17_t1 NOKX__t1 NOKX 1279.90073207
R_17_t2 NOKX__t2 NOKX 597.005875788
R_17_t3 NOKX__t3 NOKX 1204.49559346
R_17_t4 NOKX__t4 NOKX 1128.46241984
C_17 NOKX VSS 6.414389e-14
R_18_t0 KS1__t0 KS1 1204.712775
R_18_t1 KS1__t1 KS1 1204.712775
R_18_t2 KS1__t2 KS1 2409.42555
C_18 KS1 VSS 5.4330567e-14
R_19_t0 KS2__t0 KS2 1204.847775
R_19_t1 KS2__t1 KS2 1204.847775
R_19_t2 KS2__t2 KS2 2409.69555
C_19 KS2 VSS 5.4548635e-14
R_20_t0 KS3__t0 KS3 1204.98275
R_20_t1 KS3__t1 KS3 1204.98275
R_20_t2 KS3__t2 KS3 2409.9655
C_20 KS3 VSS 5.4766704e-14
R_21_t0 KS4__t0 KS4 2410.2355
R_21_t1 KS4__t1 KS4 1205.11775
R_21_t2 KS4__t2 KS4 1205.11775
C_21 KS4 VSS 5.4984773e-14
R_22_t0 NKG__t0 NKG 486.627728791
R_22_t1 NKG__t1 NKG 276.439255717
R_22_t2 NKG__t2 NKG 2120.36414661
R_22_t3 NKG__t3 NKG 1964.61916888
C_22 NKG VSS 5.7785044e-14
R_24_t0 NB__t0 NB 1961.46264717
R_24_t1 NB__t1 NB 1980.02899168
R_24_t2 NB__t2 NB 3725.54776115
C_24 NB VSS 7.6112691e-14
R_25_t0 EC__t0 EC 1152.10022722
R_25_t1 EC__t1 EC 72.3260567335
R_25_t2 EC__t2 EC 340.597144123
R_25_t3 EC__t3 EC 212.391588062
R_25_t4 EC__t4 EC 275.91173659
R_25_t5 EC__t5 EC 246.208725544
R_25_t6 EC__t6 EC 72.3260567335
R_25_t7 EC__t7 EC 144.012528403
R_25_t8 EC__t8 EC 275.91173659
C_25 EC VSS 7.4190842e-14
R_26_t0 NZ__t0 NZ 1400.6452
R_26_t1 NZ__t1 NZ 1400.6452
C_26 NZ VSS 3.1064128e-14
R_27_t0 XRZ__2__t0 XRZ__2 9.125
R_27_t1 XRZ__2__t1 XRZ__2 9.125
C_27 XRZ__2 VSS 1.8067e-15
R_28_t0 XR2__14__t0 XR2__14 9.125
R_28_t1 XR2__14__t1 XR2__14 9.125
C_28 XR2__14 VSS 1.8067e-15
R_29_t0 XR2__12__t0 XR2__12 9.125
R_29_t1 XR2__12__t1 XR2__12 9.125
C_29 XR2__12 VSS 1.8067e-15
R_3_t0 PG__t0 PG 636.433597654
R_3_t1 PG__t1 PG 503.959749741
R_3_t2 PG__t2 PG 371.362761404
R_3_t3 PG__t3 PG 883.803713976
R_3_t4 PG__t4 PG 1322.79824296
R_3_t5 PG__t5 PG 238.945693911
R_3_t6 PG__t6 PG 546.299356917
R_3_t7 PG__t7 PG 591.351383441
C_3 PG VSS 7.8120649e-14
R_30_t0 XR2__10__t0 XR2__10 9.125
R_30_t1 XR2__10__t1 XR2__10 9.125
C_30 XR2__10 VSS 1.8067e-15
R_31_t0 XR2__8__t0 XR2__8 9.125
R_31_t1 XR2__8__t1 XR2__8 9.125
C_31 XR2__8 VSS 1.8067e-15
R_32_t0 XR2__6__t0 XR2__6 9.125
R_32_t1 XR2__6__t1 XR2__6 9.125
C_32 XR2__6 VSS 1.8067e-15
R_33_t0 XR2__4__t0 XR2__4 9.125
R_33_t1 XR2__4__t1 XR2__4 9.125
C_33 XR2__4 VSS 1.8067e-15
R_34_t0 XR2__2__t0 XR2__2 9.125
R_34_t1 XR2__2__t1 XR2__2 9.125
C_34 XR2__2 VSS 1.8067e-15
R_35_t0 XRT__1__t0 XRT__1 9.125
R_35_t1 XRT__1__t1 XRT__1 9.125
C_35 XRT__1 VSS 1.8067e-15
R_36_t0 ER__t0 ER 1393.837
R_36_t1 ER__t1 ER 1393.837
C_36 ER VSS 3.3170077e-14
R_37_t0 XR1__1__t0 XR1__1 9.125
R_37_t1 XR1__1__t1 XR1__1 9.125
C_37 XR1__1 VSS 1.8067e-15
R_38_t0 XRZ__3__t0 XRZ__3 9.125
R_38_t1 XRZ__3__t1 XRZ__3 9.125
C_38 XRZ__3 VSS 1.8067e-15
R_39_t0 XRZ__1__t0 XRZ__1 9.125
R_39_t1 XRZ__1__t1 XRZ__1 9.125
C_39 XRZ__1 VSS 1.8067e-15
R_4_t0 NA__t0 NA 2219.38475185
R_4_t1 NA__t1 NA 1234.10052238
R_4_t2 NA__t2 NA 3997.24029431
R_4_t3 NA__t3 NA 557.864231464
C_4 NA VSS 8.7584412e-14
R_40_t0 XR2__7__t0 XR2__7 9.125
R_40_t1 XR2__7__t1 XR2__7 9.125
C_40 XR2__7 VSS 1.8067e-15
R_41_t0 XR2__5__t0 XR2__5 9.125
R_41_t1 XR2__5__t1 XR2__5 9.125
C_41 XR2__5 VSS 1.8067e-15
R_42_t0 XR2__3__t0 XR2__3 9.125
R_42_t1 XR2__3__t1 XR2__3 9.125
C_42 XR2__3 VSS 1.8067e-15
R_43_t0 XR2__1__t0 XR2__1 9.125
R_43_t1 XR2__1__t1 XR2__1 9.125
C_43 XR2__1 VSS 1.8067e-15
R_44_t0 XR2__15__t0 XR2__15 9.125
R_44_t1 XR2__15__t1 XR2__15 9.125
C_44 XR2__15 VSS 1.8067e-15
R_45_t0 XR2__13__t0 XR2__13 9.125
R_45_t1 XR2__13__t1 XR2__13 9.125
C_45 XR2__13 VSS 1.8067e-15
R_46_t0 XR2__11__t0 XR2__11 9.125
R_46_t1 XR2__11__t1 XR2__11 9.125
C_46 XR2__11 VSS 1.8067e-15
R_47_t0 XR2__9__t0 XR2__9 9.125
R_47_t1 XR2__9__t1 XR2__9 9.125
C_47 XR2__9 VSS 1.8067e-15
R_5_t0 NBTOP__t0 NBTOP 3898.24002795
R_5_t1 NBTOP__t1 NBTOP 2571.04128444
R_5_t2 NBTOP__t2 NBTOP 1327.4843876
C_5 NBTOP VSS 7.8319844e-14
R_7_t0 NBG__t0 NBG 2435.8789
R_7_t1 NBG__t1 NBG 734.293929275
R_7_t2 NBG__t2 NBG 967.291041449
R_7_t3 NBG__t3 NBG 734.293929275
C_7 NBG VSS 5.5851412e-14
R_8_t0 PB__t0 PB 732.273832504
R_8_t1 PB__t1 PB 171.628406437
R_8_t2 PB__t2 PB 1341.19339542
R_8_t3 PB__t3 PB 783.709475137
R_8_t4 PB__t4 PB 321.870246222
R_8_t5 PB__t5 PB 769.394856997
R_8_t6 PB__t6 PB 46.1556265021
R_8_t7 PB__t7 PB 460.379603783
R_8_t8 PB__t8 PB 769.394856997
C_8 PB VSS 7.9168117e-14
RBIAS_OK_t0 BIAS_OK__t0 BIAS_OK 2339.5192
RBIAS_OK_t1 BIAS_OK__t1 BIAS_OK 2339.5192
CBIAS_OK BIAS_OK VSS 4.7753184e-14
RIBIAS_t0 IBIAS__t0 IBIAS 4663.4113
CIBIAS IBIAS VSS 4.1483963e-14
RVDD_t0 VDD__t0 VDD 18.3490381511
RVDD_t1 VDD__t1 VDD 18.3490381511
RVDD_t2 VDD__t2 VDD 12.5597109297
RVDD_t3 VDD__t3 VDD 12.5597109297
RVDD_t4 VDD__t4 VDD 9.59042869478
RVDD_t5 VDD__t5 VDD 9.59042869478
RVDD_t6 VDD__t6 VDD 4.73655855287
RVDD_t7 VDD__t7 VDD 1.89786481854
RVDD_t8 VDD__t8 VDD 1.89786481854
RVDD_t9 VDD__t9 VDD 70.0069054947
RVDD_t10 VDD__t10 VDD 28.0088605711
RVDD_t11 VDD__t11 VDD 28.0088605711
RVDD_t12 VDD__t12 VDD 9.10556563512
RVDD_t13 VDD__t13 VDD 11.0357462885
RVDD_t14 VDD__t14 VDD 3.46407886324
RVDD_t15 VDD__t15 VDD 9.10556563512
RVDD_t16 VDD__t16 VDD 11.0357462885
RVDD_t17 VDD__t17 VDD 3.46407886324
RVDD_t18 VDD__t18 VDD 2.82384916305
RVDD_t19 VDD__t19 VDD 1.55071553575
RVDD_t20 VDD__t20 VDD 6.76663189187
RVDD_t21 VDD__t21 VDD 10.6210666462
RVDD_t22 VDD__t22 VDD 1.55071553575
RVDD_t23 VDD__t23 VDD 6.76663189187
RVDD_t24 VDD__t24 VDD 10.6210666462
RVDD_t25 VDD__t25 VDD 7.04564561945
RVDD_t26 VDD__t26 VDD 5.09940792054
RVDD_t27 VDD__t27 VDD 14.4468201801
RVDD_t28 VDD__t28 VDD 16.3978384187
RVDD_t29 VDD__t29 VDD 14.4468201801
RVDD_t30 VDD__t30 VDD 16.3978384187
CVDD VDD VSS 1.50745094e-13
RVREF_t0 VREF__t0 VREF 3847.79075
RVREF_t1 VREF__t1 VREF 3847.79075
CVREF VREF VSS 7.3507489e-14
RVSS_t0 VSS__t0 VSS 3.62269552421
RVSS_t1 VSS__t1 VSS 3.3142902479
RVSS_t2 VSS__t2 VSS 2.88296407502
RVSS_t3 VSS__t3 VSS 1.61606765031
RVSS_t4 VSS__t4 VSS 1.55518591813
RVSS_t5 VSS__t5 VSS 1.28720407093
RVSS_t6 VSS__t6 VSS 1.15492128112
RVSS_t7 VSS__t7 VSS 0.046541739734
RVSS_t8 VSS__t8 VSS 0.707450333327
RVSS_t9 VSS__t9 VSS 0.668726372543
RVSS_t10 VSS__t10 VSS 0.905709610457
RVSS_t11 VSS__t11 VSS 0.356890791398
RVSS_t12 VSS__t12 VSS 0.465423457835
RVSS_t13 VSS__t13 VSS 0.732422637179
RVSS_t14 VSS__t14 VSS 0.612601885956
RVSS_t15 VSS__t15 VSS 0.302347633786
RVSS_t16 VSS__t16 VSS 0.989430125904
RVSS_t17 VSS__t17 VSS 3.1048655595
RVSS_t18 VSS__t18 VSS 3.49123124431
RVSS_t19 VSS__t19 VSS 1.76382681958
RVSS_t20 VSS__t20 VSS 1.44804434787
RVSS_t21 VSS__t21 VSS 1.22563529906
RVSS_t22 VSS__t22 VSS 1.35429122161
RVSS_t23 VSS__t23 VSS 0.668726372543
RVSS_t24 VSS__t24 VSS 0.732422637179
RVSS_t25 VSS__t25 VSS 0.905709610457
RVSS_t26 VSS__t26 VSS 0.356890791398
RVSS_t27 VSS__t27 VSS 0.465423457835
RVSS_t28 VSS__t28 VSS 0.707450333327
RVSS_t29 VSS__t29 VSS 0.989430125904
RVSS_t30 VSS__t30 VSS 0.046541739734
RVSS_t31 VSS__t31 VSS 0.302347633786
RVSS_t32 VSS__t32 VSS 0.612601885956
RVSS_t33 VSS__t33 VSS 2.30792864672
RVSS_t34 VSS__t34 VSS 2.34411808708
RVSS_t35 VSS__t35 VSS 2.41970118491
RVSS_t36 VSS__t36 VSS 2.49923129895
RVSS_t37 VSS__t37 VSS 2.58234377852
RVSS_t38 VSS__t38 VSS 2.6687039436
RVSS_t39 VSS__t39 VSS 2.75800673132
RVSS_t40 VSS__t40 VSS 2.84997553758
RVSS_t41 VSS__t41 VSS 2.38139231014
RVSS_t42 VSS__t42 VSS 2.45899635513
RVSS_t43 VSS__t43 VSS 2.54036136359
RVSS_t44 VSS__t44 VSS 2.6251376505
RVSS_t45 VSS__t45 VSS 2.71300544671
RVSS_t46 VSS__t46 VSS 2.80367410143
RVSS_t47 VSS__t47 VSS 2.89688063673
RVSS_t48 VSS__t48 VSS 2.94436054908
RVSS_t49 VSS__t49 VSS 3.04119063361
RVSS_t50 VSS__t50 VSS 3.09065224382
RVSS_t51 VSS__t51 VSS 3.14057429069
RVSS_t52 VSS__t52 VSS 3.19093516376
RVSS_t53 VSS__t53 VSS 2.92596660779
RVSS_t54 VSS__t54 VSS 2.9843073127
RVSS_t55 VSS__t55 VSS 3.01812698801
RVSS_t56 VSS__t56 VSS 3.07893638539
RVSS_t57 VSS__t57 VSS 2.70306155616
RVSS_t58 VSS__t58 VSS 2.50075534872
RVSS_t59 VSS__t59 VSS 2.30178219345
RVSS_t60 VSS__t60 VSS 2.10708652698
RVSS_t61 VSS__t61 VSS 1.91797143161
RVSS_t62 VSS__t62 VSS 1.55518591813
RVSS_t63 VSS__t63 VSS 3.62269552421
RVSS_t64 VSS__t64 VSS 3.49123124431
RVSS_t65 VSS__t65 VSS 1.76382681958
RVSS_t66 VSS__t66 VSS 1.44804434787
RVSS_t67 VSS__t67 VSS 1.35429122161
RVSS_t68 VSS__t68 VSS 1.22563529906
RVSS_t69 VSS__t69 VSS 1.28720407093
RVSS_t70 VSS__t70 VSS 3.3142902479
RVSS_t71 VSS__t71 VSS 3.1048655595
RVSS_t72 VSS__t72 VSS 1.15492128112
RVSS_t73 VSS__t73 VSS 2.88296407502
RVSS_t74 VSS__t74 VSS 1.61606765031
CVSS VSS VSS 2.53061568e-13
Ccc__12__3 N2 PG 1.1805e-17
Ccc__17__26 NOKX NZ 1.4757e-17
Ccc__17__3 NOKX PG 1.4757e-17
Ccc__17_VDD NOKX VDD 7.7718e-17
Ccc__24__3 NB PG 1.1805e-17
Ccc__25__3 EC PG 1.5347e-16
Ccc__26__3 NZ PG 2.30203e-16
Ccc__3__4 PG NA 1.1805e-17
Ccc__3__5 PG NBTOP 1.1805e-17
Ccc__3_VREF PG VREF 1.1805e-17
Ccc__3_VSS PG VSS 3.5416e-17
Rvsubs_dctie VSS 0 1e+12
.ends bias_core

* temp_core -- post-layout netlist
* GENERATED by layout/postlayout.py -- do not edit.
*
* FROM THE LAYOUT: every device and its dimensions, the whole
*   topology, and first-order interconnect R/C on 69/69 nets
*   (sigma 1740.7 fF, of which 3.071 fF is net-to-net coupling).
*   One star per net: <net> is the hub, <net>__t<k> each device
*   terminal on it, R<net>_t<k> the arm between them.
*   klt 0.6.0, deck gf180mcu,
*   GDS sha256 ffcb31808d178846...
* Net names are the schematic's, restored through klt lvs's own net
*   correspondence -- match, 69/69 nets, every one paired.
*
* NOT FROM THE LAYOUT -- see layout/postlayout/AUDIT.md:
*   4 body/plate net(s) tied to the net the schematic puts
*   them on. The extraction deck's connectivity stack does not reach
*   an Nwell, a substrate ring, a bipolar base well or a MiM plate,
*   so they extract isolated and would otherwise float.
*   No ideal device: every golden device is drawn.
*
.subckt temp_core VDD VSS IBIAS EN PTAT CTAT

* --- drawn devices ---
X1 VSS__t87 VSS__t88 VSS__t86 VSS__t59 nfet_03v3 L=8u W=4u nf=1 ad=3.2p as=3.2p pd=9.6u ps=9.6u m=1
X2 N1__t7 N1__t5 VSS__t119 VSS__t60 nfet_03v3 L=8u W=4u nf=1 ad=3.2p as=3.2p pd=9.6u ps=9.6u m=1
X3 N2__t5 N1__t2 VSS__t115 VSS__t61 nfet_03v3 L=8u W=4u nf=1 ad=3.2p as=3.2p pd=9.6u ps=9.6u m=1
X4 N2__t6 N1__t3 VSS__t116 VSS__t62 nfet_03v3 L=8u W=4u nf=1 ad=3.2p as=3.2p pd=9.6u ps=9.6u m=1
X5 N1__t6 N1__t4 VSS__t117 VSS__t63 nfet_03v3 L=8u W=4u nf=1 ad=3.2p as=3.2p pd=9.6u ps=9.6u m=1
X6 VSS__t114 VSS__t113 VSS__t118 VSS__t64 nfet_03v3 L=8u W=4u nf=1 ad=3.2p as=3.2p pd=9.6u ps=9.6u m=1
X7 PG__t0 N2__t0 VSS__t89 VSS__t65 nfet_03v3 L=8u W=8u nf=1 ad=6.4p as=6.4p pd=17.6u ps=17.6u m=1
X8 IBIAS__t1 NBG__t0 VSS__t90 VSS__t66 nfet_03v3 L=2u W=4u nf=1 ad=3.2p as=3.2p pd=9.6u ps=9.6u m=1
X9 IBIAS__t0 EN__t0 NBG__t2 VSS__t69 nfet_03v3 L=0.5u W=2u nf=1 ad=1.6p as=1.6p pd=5.6u ps=5.6u m=1
X10 NBG__t1 ENB__t6 VSS__t92 VSS__t70 nfet_03v3 L=0.5u W=2u nf=1 ad=1.6p as=1.6p pd=5.6u ps=5.6u m=1
X11 PB__t5 NBG__t4 VSS__t112 VSS__t67 nfet_03v3 L=2u W=4u nf=1 ad=3.2p as=3.2p pd=9.6u ps=9.6u m=1
X12 PCAS__t0 NBG__t3 VSS__t111 VSS__t68 nfet_03v3 L=2u W=4u nf=1 ad=3.2p as=3.2p pd=9.6u ps=9.6u m=1
X13 ENB__t0 EN__t1 VSS__t93 VSS__t72 nfet_03v3 L=0.5u W=1u nf=1 ad=0.8p as=0.8p pd=3.6u ps=3.6u m=1
X14 ND__t1 NR__t0 VSS__t94 VSS__t73 nfet_03v3 L=2u W=2u nf=1 ad=1.6p as=1.6p pd=5.6u ps=5.6u m=1
X15 PG__t1 ND__t0 VSS__t91 VSS__t75 nfet_03v3 L=1u W=4u nf=1 ad=3.2p as=3.2p pd=9.6u ps=9.6u m=1
X16 NR__t3 NR__t2 VSS__t109 VSS__t74 nfet_03v3 L=2u W=2u nf=1 ad=1.6p as=1.6p pd=5.6u ps=5.6u m=1
X17 ND__t3 ENB__t7 VSS__t110 VSS__t71 nfet_03v3 L=0.5u W=2u nf=1 ad=1.6p as=1.6p pd=5.6u ps=5.6u m=1
X18 PTAT__t0 ENB__t1 VSS__t95 VSS__t76 nfet_03v3 L=1u W=1u nf=1 ad=0.8p as=0.8p pd=3.6u ps=3.6u m=1
X19 CTAT__t1 ENB__t5 VSS__t108 VSS__t77 nfet_03v3 L=1u W=1u nf=1 ad=0.8p as=0.8p pd=3.6u ps=3.6u m=1
X20 N2__t1 ENB__t2 VSS__t96 VSS__t78 nfet_03v3 L=1u W=2u nf=1 ad=1.6p as=1.6p pd=5.6u ps=5.6u m=1
X21 NT__t17 ENB__t4 VSS__t107 VSS__t79 nfet_03v3 L=1u W=2u nf=1 ad=1.6p as=1.6p pd=5.6u ps=5.6u m=1
X22 T5__t0 VDD__t0 T4__t0 VSS__t80 nfet_03v3 L=0.5u W=32u nf=1 ad=25.6p as=25.6p pd=65.6u ps=65.6u m=1
X23 T3__t2 VSS__t121 T2__t3 VSS__t81 nfet_03v3 L=0.5u W=32u nf=1 ad=25.6p as=25.6p pd=65.6u ps=65.6u m=1
X24 T1__t2 VSS__t122 T0__t3 VSS__t82 nfet_03v3 L=0.5u W=32u nf=1 ad=25.6p as=25.6p pd=65.6u ps=65.6u m=1
X25 T0__t2 VSS__t123 VSS__t120 VSS__t83 nfet_03v3 L=0.5u W=32u nf=1 ad=25.6p as=25.6p pd=65.6u ps=65.6u m=1
X26 T2__t2 VSS__t124 T1__t3 VSS__t84 nfet_03v3 L=0.5u W=32u nf=1 ad=25.6p as=25.6p pd=65.6u ps=65.6u m=1
X27 T4__t3 VSS__t125 T3__t3 VSS__t85 nfet_03v3 L=0.5u W=32u nf=1 ad=25.6p as=25.6p pd=65.6u ps=65.6u m=1
X28 NT__t1 NT__t2 NT__t0 NT__t3 pfet_03v3 L=4u W=16u nf=1 ad=12.8p as=12.8p pd=33.6u ps=33.6u m=1
X29 N1__t0 NA__t4 NT__t12 NT__t5 pfet_03v3 L=4u W=16u nf=1 ad=12.8p as=12.8p pd=33.6u ps=33.6u m=1
X30 N2__t4 NB__t4 NT__t16 NT__t9 pfet_03v3 L=4u W=16u nf=1 ad=12.8p as=12.8p pd=33.6u ps=33.6u m=1
X31 N2__t3 NB__t3 NT__t15 NT__t8 pfet_03v3 L=4u W=16u nf=1 ad=12.8p as=12.8p pd=33.6u ps=33.6u m=1
X32 N1__t1 NA__t5 NT__t14 NT__t7 pfet_03v3 L=4u W=16u nf=1 ad=12.8p as=12.8p pd=33.6u ps=33.6u m=1
X33 NT__t11 NT__t10 NT__t13 NT__t6 pfet_03v3 L=4u W=16u nf=1 ad=12.8p as=12.8p pd=33.6u ps=33.6u m=1
X34 NT__t4 PB__t0 VDD__t1 VDD__t2 pfet_03v3 L=4u W=20u nf=1 ad=16p as=16p pd=41.6u ps=41.6u m=1
X35 VDD__t4 VDD__t5 VDD__t3 VDD__t6 pfet_03v3 L=4u W=4u nf=1 ad=3.2p as=3.2p pd=9.6u ps=9.6u m=1
X36 M1D__t3 PG__t9 VDD__t39 VDD__t30 pfet_03v3 L=4u W=4u nf=1 ad=3.2p as=3.2p pd=9.6u ps=9.6u m=1
X37 NA__t0 PCAS__t1 M1D__t0 VDD__t7 pfet_03v3 L=1u W=4u nf=1 ad=3.2p as=3.2p pd=9.6u ps=9.6u m=1
X38 M2D__t3 PG__t11 VDD__t41 VDD__t32 pfet_03v3 L=4u W=4u nf=1 ad=3.2p as=3.2p pd=9.6u ps=9.6u m=1
X39 NB__t2 PCAS__t8 M2D__t1 VDD__t26 pfet_03v3 L=1u W=4u nf=1 ad=3.2p as=3.2p pd=9.6u ps=9.6u m=1
X40 M3D__t3 PG__t10 VDD__t40 VDD__t31 pfet_03v3 L=4u W=4u nf=1 ad=3.2p as=3.2p pd=9.6u ps=9.6u m=1
X41 PTAT__t3 PCAS__t7 M3D__t1 VDD__t25 pfet_03v3 L=1u W=4u nf=1 ad=3.2p as=3.2p pd=9.6u ps=9.6u m=1
X42 PTAT__t2 PCAS__t6 M3D__t0 VDD__t24 pfet_03v3 L=1u W=4u nf=1 ad=3.2p as=3.2p pd=9.6u ps=9.6u m=1
X43 M3D__t2 PG__t8 VDD__t38 VDD__t29 pfet_03v3 L=4u W=4u nf=1 ad=3.2p as=3.2p pd=9.6u ps=9.6u m=1
X44 NB__t1 PCAS__t4 M2D__t0 VDD__t22 pfet_03v3 L=1u W=4u nf=1 ad=3.2p as=3.2p pd=9.6u ps=9.6u m=1
X45 M2D__t2 PG__t7 VDD__t37 VDD__t28 pfet_03v3 L=4u W=4u nf=1 ad=3.2p as=3.2p pd=9.6u ps=9.6u m=1
X46 NA__t3 PCAS__t5 M1D__t1 VDD__t23 pfet_03v3 L=1u W=4u nf=1 ad=3.2p as=3.2p pd=9.6u ps=9.6u m=1
X47 M1D__t2 PG__t6 VDD__t36 VDD__t27 pfet_03v3 L=4u W=4u nf=1 ad=3.2p as=3.2p pd=9.6u ps=9.6u m=1
X48 VDD__t35 VDD__t34 VDD__t42 VDD__t33 pfet_03v3 L=4u W=4u nf=1 ad=3.2p as=3.2p pd=9.6u ps=9.6u m=1
X49 PG__t2 PB__t1 VDD__t8 VDD__t9 pfet_03v3 L=4u W=10u nf=1 ad=8p as=8p pd=21.6u ps=21.6u m=1
X50 PB__t4 PB__t3 VDD__t21 VDD__t20 pfet_03v3 L=4u W=10u nf=1 ad=8p as=8p pd=21.6u ps=21.6u m=1
X51 PCAS__t2 PCAS__t3 VDD__t10 VDD__t11 pfet_03v3 L=8u W=1u nf=1 ad=0.8p as=0.8p pd=3.6u ps=3.6u m=1
X52 ENB__t3 EN__t2 VDD__t12 VDD__t13 pfet_03v3 L=0.5u W=2u nf=1 ad=1.6p as=1.6p pd=5.6u ps=5.6u m=1
X53 ND__t2 PB__t2 VDD__t19 VDD__t18 pfet_03v3 L=8u W=1u nf=1 ad=0.8p as=0.8p pd=3.6u ps=3.6u m=1
X54 NR__t1 PG__t3 VDD__t14 VDD__t15 pfet_03v3 L=4u W=1u nf=1 ad=0.8p as=0.8p pd=3.6u ps=3.6u m=1
X55 PG__t4 EN__t3 VDD__t16 VDD__t17 pfet_03v3 L=0.5u W=4u nf=1 ad=3.2p as=3.2p pd=9.6u ps=9.6u m=1
X56 VSS__t0 VSS__t97 NC__t1 pnp_10p00x10p00
X57 VSS__t1 VSS__t105 NC__t8 pnp_10p00x10p00
X58 VSS__t2 VSS__t98 NC__t2 pnp_10p00x10p00
X59 VSS__t3 VSS__t99 NC__t3 pnp_10p00x10p00
X60 VSS__t4 VSS__t100 NA__t2 pnp_10p00x10p00
X61 VSS__t5 VSS__t101 NC__t4 pnp_10p00x10p00
X62 VSS__t6 VSS__t102 NC__t5 pnp_10p00x10p00
X63 VSS__t7 VSS__t103 NC__t6 pnp_10p00x10p00
X64 VSS__t8 VSS__t104 NC__t7 pnp_10p00x10p00
X65 PG__t5 NZ__t1 cap_mim_2f0_m3m4_noshield c_width=12u c_length=12u
X66 NB__t0 XR1__1__t0 VSS__t9 ppolyf_u r_width=2u r_length=59.735u
X67 NC__t0 XR1__1__t1 VSS__t10 ppolyf_u r_width=2u r_length=59.735u
X68 NA__t1 XRISO__1__t0 VSS__t11 ppolyf_u r_width=2u r_length=55.525u
X69 CTAT__t0 XRISO__1__t1 VSS__t12 ppolyf_u r_width=2u r_length=55.525u
X70 NZ__t0 XRZ__1__t0 VSS__t13 ppolyf_u r_width=2u r_length=100u
X71 XRZ__2__t0 XRZ__1__t1 VSS__t14 ppolyf_u r_width=2u r_length=100u
X72 XRZ__2__t1 XRZ__3__t1 VSS__t15 ppolyf_u r_width=2u r_length=100u
X73 XRZ__4__t1 XRZ__3__t0 VSS__t16 ppolyf_u r_width=2u r_length=100u
X74 XRZ__4__t0 XRZ__5__t1 VSS__t17 ppolyf_u r_width=2u r_length=100u
X75 XRZ__6__t1 XRZ__5__t0 VSS__t18 ppolyf_u r_width=2u r_length=100u
X76 XRZ__6__t0 XRZ__7__t1 VSS__t19 ppolyf_u r_width=2u r_length=100u
X77 XRZ__8__t1 XRZ__7__t0 VSS__t20 ppolyf_u r_width=2u r_length=100u
X78 XRZ__8__t0 XRZ__9__t1 VSS__t21 ppolyf_u r_width=2u r_length=100u
X79 N2__t2 XRZ__9__t0 VSS__t22 ppolyf_u r_width=2u r_length=100u
X80 PTAT__t1 XR2F__1__t0 VSS__t23 ppolyf_u r_width=2u r_length=110.525u
X81 XR2F__2__t1 XR2F__1__t1 VSS__t24 ppolyf_u r_width=2u r_length=110.525u
X82 XR2F__2__t0 XR2F__3__t1 VSS__t25 ppolyf_u r_width=2u r_length=110.525u
X83 XR2F__4__t1 XR2F__3__t0 VSS__t26 ppolyf_u r_width=2u r_length=110.525u
X84 XR2F__4__t0 XR2F__5__t1 VSS__t27 ppolyf_u r_width=2u r_length=110.525u
X85 XR2F__6__t1 XR2F__5__t0 VSS__t28 ppolyf_u r_width=2u r_length=110.525u
X86 XR2F__6__t0 XR2F__7__t1 VSS__t29 ppolyf_u r_width=2u r_length=110.525u
X87 XR2F__8__t1 XR2F__7__t0 VSS__t30 ppolyf_u r_width=2u r_length=110.525u
X88 XR2F__8__t0 XR2F__9__t1 VSS__t31 ppolyf_u r_width=2u r_length=110.525u
X89 XR2F__10__t1 XR2F__9__t0 VSS__t32 ppolyf_u r_width=2u r_length=110.525u
X90 XR2F__10__t0 XR2F__11__t1 VSS__t33 ppolyf_u r_width=2u r_length=110.525u
X91 XR2F__12__t1 XR2F__11__t0 VSS__t34 ppolyf_u r_width=2u r_length=110.525u
X92 XR2F__12__t0 XR2F__13__t1 VSS__t35 ppolyf_u r_width=2u r_length=110.525u
X93 XR2F__14__t1 XR2F__13__t0 VSS__t36 ppolyf_u r_width=2u r_length=110.525u
X94 XR2F__14__t0 XR2F__15__t1 VSS__t37 ppolyf_u r_width=2u r_length=110.525u
X95 XR2F__16__t1 XR2F__15__t0 VSS__t38 ppolyf_u r_width=2u r_length=110.525u
X96 XR2F__16__t0 XR2F__17__t1 VSS__t39 ppolyf_u r_width=2u r_length=110.525u
X97 XR2F__18__t0 XR2F__17__t0 VSS__t40 ppolyf_u r_width=2u r_length=110.525u
X98 XR2F__18__t1 XR2F__19__t1 VSS__t41 ppolyf_u r_width=2u r_length=110.525u
X99 XR2F__20__t0 XR2F__19__t0 VSS__t42 ppolyf_u r_width=2u r_length=110.525u
X100 XR2F__20__t1 XR2F__21__t0 VSS__t43 ppolyf_u r_width=2u r_length=110.525u
X101 XR2F__22__t0 XR2F__21__t1 VSS__t44 ppolyf_u r_width=2u r_length=110.525u
X102 XR2F__22__t1 XR2F__23__t0 VSS__t45 ppolyf_u r_width=2u r_length=110.525u
X103 T5__t2 XR2F__23__t1 VSS__t46 ppolyf_u r_width=2u r_length=110.525u
X104 T5__t1 XR2T5__1__t0 VSS__t47 ppolyf_u r_width=2u r_length=114.855u
X105 T4__t2 XR2T5__1__t1 VSS__t48 ppolyf_u r_width=2u r_length=114.855u
X106 T4__t1 XR2T4__1__t0 VSS__t49 ppolyf_u r_width=2u r_length=57.345u
X107 T3__t1 XR2T4__1__t1 VSS__t50 ppolyf_u r_width=2u r_length=57.345u
X108 T3__t0 XR2T3__1__t0 VSS__t51 ppolyf_u r_width=2u r_length=28.59u
X109 T2__t1 XR2T3__1__t1 VSS__t52 ppolyf_u r_width=2u r_length=28.59u
X110 T2__t0 XR2T2__1__t0 VSS__t53 ppolyf_u r_width=2u r_length=14.21u
X111 T1__t1 XR2T2__1__t1 VSS__t54 ppolyf_u r_width=2u r_length=14.21u
X112 T1__t0 XR2T1__1__t0 VSS__t55 ppolyf_u r_width=2u r_length=7.015u
X113 T0__t1 XR2T1__1__t1 VSS__t56 ppolyf_u r_width=2u r_length=7.015u
X114 T0__t0 XR2T0__1__t0 VSS__t57 ppolyf_u r_width=2u r_length=3.425u
X115 VSS__t106 XR2T0__1__t1 VSS__t58 ppolyf_u r_width=2u r_length=3.425u

R_28_t0 XRZ__2__t0 XRZ__2 25.28745
R_28_t1 XRZ__2__t1 XRZ__2 25.28745
C_28 XRZ__2 VSS 1.599507e-15
R_29_t0 XRZ__4__t0 XRZ__4 25.28745
R_29_t1 XRZ__4__t1 XRZ__4 25.28745
C_29 XRZ__4 VSS 1.599507e-15
R_30_t0 XRZ__6__t0 XRZ__6 25.28745
R_30_t1 XRZ__6__t1 XRZ__6 25.28745
C_30 XRZ__6 VSS 1.599507e-15
R_31_t0 XRZ__8__t0 XRZ__8 25.28745
R_31_t1 XRZ__8__t1 XRZ__8 25.28745
C_31 XRZ__8 VSS 1.599507e-15
R_32_t0 XR2F__2__t0 XR2F__2 25.28745
R_32_t1 XR2F__2__t1 XR2F__2 25.28745
C_32 XR2F__2 VSS 1.599507e-15
R_33_t0 XR2F__4__t0 XR2F__4 25.28745
R_33_t1 XR2F__4__t1 XR2F__4 25.28745
C_33 XR2F__4 VSS 1.599507e-15
R_34_t0 XR2F__6__t0 XR2F__6 25.28745
R_34_t1 XR2F__6__t1 XR2F__6 25.28745
C_34 XR2F__6 VSS 1.599507e-15
R_35_t0 XR2F__8__t0 XR2F__8 25.28745
R_35_t1 XR2F__8__t1 XR2F__8 25.28745
C_35 XR2F__8 VSS 1.599507e-15
R_36_t0 XR2F__10__t0 XR2F__10 25.28745
R_36_t1 XR2F__10__t1 XR2F__10 25.28745
C_36 XR2F__10 VSS 1.599507e-15
R_37_t0 XR2F__12__t0 XR2F__12 25.28745
R_37_t1 XR2F__12__t1 XR2F__12 25.28745
C_37 XR2F__12 VSS 1.599507e-15
R_38_t0 XR2F__14__t0 XR2F__14 25.28745
R_38_t1 XR2F__14__t1 XR2F__14 25.28745
C_38 XR2F__14 VSS 1.599507e-15
R_39_t0 XR2F__16__t0 XR2F__16 25.28745
R_39_t1 XR2F__16__t1 XR2F__16 25.28745
C_39 XR2F__16 VSS 1.599507e-15
R_40_t0 XR2F__18__t0 XR2F__18 25.28745
R_40_t1 XR2F__18__t1 XR2F__18 25.28745
C_40 XR2F__18 VSS 1.599507e-15
R_41_t0 XR2F__20__t0 XR2F__20 25.28745
R_41_t1 XR2F__20__t1 XR2F__20 25.28745
C_41 XR2F__20 VSS 1.599507e-15
R_42_t0 XR2F__22__t0 XR2F__22 25.28745
R_42_t1 XR2F__22__t1 XR2F__22 25.28745
C_42 XR2F__22 VSS 1.599507e-15
R_48_t0 XR2T0__1__t0 XR2T0__1 25.28745
R_48_t1 XR2T0__1__t1 XR2T0__1 25.28745
C_48 XR2T0__1 VSS 1.599507e-15
R_49_t0 XR2T1__1__t0 XR2T1__1 25.28745
R_49_t1 XR2T1__1__t1 XR2T1__1 25.28745
C_49 XR2T1__1 VSS 1.599507e-15
R_53_t0 XR2T2__1__t0 XR2T2__1 25.28745
R_53_t1 XR2T2__1__t1 XR2T2__1 25.28745
C_53 XR2T2__1 VSS 1.599507e-15
R_57_t0 XR2T3__1__t0 XR2T3__1 25.28745
R_57_t1 XR2T3__1__t1 XR2T3__1 25.28745
C_57 XR2T3__1 VSS 1.599507e-15
R_65_t0 XRISO__1__t0 XRISO__1 25.28745
R_65_t1 XRISO__1__t1 XRISO__1 25.28745
C_65 XRISO__1 VSS 1.599507e-15
R_66_t0 XR2T4__1__t0 XR2T4__1 25.28745
R_66_t1 XR2T4__1__t1 XR2T4__1 25.28745
C_66 XR2T4__1 VSS 1.599507e-15
R_67_t0 XR1__1__t0 XR1__1 25.28745
R_67_t1 XR1__1__t1 XR1__1 25.28745
C_67 XR1__1 VSS 1.599507e-15
R_68_t0 XRZ__1__t0 XRZ__1 25.28745
R_68_t1 XRZ__1__t1 XRZ__1 25.28745
C_68 XRZ__1 VSS 1.599507e-15
R_69_t0 XRZ__3__t0 XRZ__3 25.28745
R_69_t1 XRZ__3__t1 XRZ__3 25.28745
C_69 XRZ__3 VSS 1.599507e-15
R_70_t0 XRZ__5__t0 XRZ__5 25.28745
R_70_t1 XRZ__5__t1 XRZ__5 25.28745
C_70 XRZ__5 VSS 1.599507e-15
R_71_t0 XRZ__7__t0 XRZ__7 25.28745
R_71_t1 XRZ__7__t1 XRZ__7 25.28745
C_71 XRZ__7 VSS 1.599507e-15
R_72_t0 XRZ__9__t0 XRZ__9 25.28745
R_72_t1 XRZ__9__t1 XRZ__9 25.28745
C_72 XRZ__9 VSS 1.599507e-15
R_73_t0 XR2F__1__t0 XR2F__1 25.28745
R_73_t1 XR2F__1__t1 XR2F__1 25.28745
C_73 XR2F__1 VSS 1.599507e-15
R_74_t0 XR2F__3__t0 XR2F__3 25.28745
R_74_t1 XR2F__3__t1 XR2F__3 25.28745
C_74 XR2F__3 VSS 1.599507e-15
R_75_t0 XR2F__5__t0 XR2F__5 25.28745
R_75_t1 XR2F__5__t1 XR2F__5 25.28745
C_75 XR2F__5 VSS 1.599507e-15
R_76_t0 XR2F__7__t0 XR2F__7 25.28745
R_76_t1 XR2F__7__t1 XR2F__7 25.28745
C_76 XR2F__7 VSS 1.599507e-15
R_77_t0 XR2F__9__t0 XR2F__9 25.28745
R_77_t1 XR2F__9__t1 XR2F__9 25.28745
C_77 XR2F__9 VSS 1.599507e-15
R_78_t0 XR2F__11__t0 XR2F__11 25.28745
R_78_t1 XR2F__11__t1 XR2F__11 25.28745
C_78 XR2F__11 VSS 1.599507e-15
R_79_t0 XR2F__13__t0 XR2F__13 25.28745
R_79_t1 XR2F__13__t1 XR2F__13 25.28745
C_79 XR2F__13 VSS 1.599507e-15
R_80_t0 XR2F__15__t0 XR2F__15 25.28745
R_80_t1 XR2F__15__t1 XR2F__15 25.28745
C_80 XR2F__15 VSS 1.599507e-15
R_81_t0 XR2F__17__t0 XR2F__17 25.28745
R_81_t1 XR2F__17__t1 XR2F__17 25.28745
C_81 XR2F__17 VSS 1.599507e-15
R_82_t0 XR2F__19__t0 XR2F__19 25.28745
R_82_t1 XR2F__19__t1 XR2F__19 25.28745
C_82 XR2F__19 VSS 1.599507e-15
R_83_t0 XR2F__21__t0 XR2F__21 25.28745
R_83_t1 XR2F__21__t1 XR2F__21 25.28745
C_83 XR2F__21 VSS 1.599507e-15
R_84_t0 XR2F__23__t0 XR2F__23 25.28745
R_84_t1 XR2F__23__t1 XR2F__23 25.28745
C_84 XR2F__23 VSS 1.599507e-15
R_85_t0 XR2T5__1__t0 XR2T5__1 25.28745
R_85_t1 XR2T5__1__t1 XR2T5__1 25.28745
C_85 XR2T5__1 VSS 1.599507e-15
RCTAT_t0 CTAT__t0 CTAT 258.65425
RCTAT_t1 CTAT__t1 CTAT 258.65425
CCTAT CTAT VSS 3.5379154e-14
REN_t0 EN__t0 EN 488.922518209
REN_t1 EN__t1 EN 238.763338727
REN_t2 EN__t2 EN 236.947742703
REN_t3 EN__t3 EN 508.553700361
CEN EN VSS 3.3695736e-14
RENB_t0 ENB__t0 ENB 171.908381309
RENB_t1 ENB__t1 ENB 137.876093758
RENB_t2 ENB__t2 ENB 189.999228044
RENB_t3 ENB__t3 ENB 326.623923902
RENB_t4 ENB__t4 ENB 215.772604212
RENB_t5 ENB__t5 ENB 163.414676184
RENB_t6 ENB__t6 ENB 421.059618338
RENB_t7 ENB__t7 ENB 95.6628742538
CENB ENB VSS 3.6396628e-14
RIBIAS_t0 IBIAS__t0 IBIAS 161.3252
RIBIAS_t1 IBIAS__t1 IBIAS 161.3252
CIBIAS IBIAS VSS 2.0274985e-14
RM1D_t0 M1D__t0 M1D 297.344707753
RM1D_t1 M1D__t1 M1D 297.344707753
RM1D_t2 M1D__t2 M1D 365.905392247
RM1D_t3 M1D__t3 M1D 365.905392247
CM1D M1D VSS 2.6572254e-14
RM2D_t0 M2D__t0 M2D 257.619878352
RM2D_t1 M2D__t1 M2D 257.619878352
RM2D_t2 M2D__t2 M2D 367.857221648
RM2D_t3 M2D__t3 M2D 367.857221648
CM2D M2D VSS 2.5181332e-14
RM3D_t0 M3D__t0 M3D 118.304635714
RM3D_t1 M3D__t1 M3D 118.304635714
RM3D_t2 M3D__t2 M3D 469.402264286
RM3D_t3 M3D__t3 M3D 469.402264286
CM3D M3D VSS 2.3790409e-14
RN1_t0 N1__t0 N1 1046.59861862
RN1_t1 N1__t1 N1 801.166547704
RN1_t2 N1__t2 N1 243.963010283
RN1_t3 N1__t3 N1 378.085819054
RN1_t4 N1__t4 N1 534.627163629
RN1_t5 N1__t5 N1 188.503038543
RN1_t6 N1__t6 N1 534.627163629
RN1_t7 N1__t7 N1 188.503038543
CN1 N1 VSS 3.9158003e-14
RN2_t0 N2__t0 N2 145.839569879
RN2_t1 N2__t1 N2 392.018582259
RN2_t2 N2__t2 N2 667.28572049
RN2_t3 N2__t3 N2 356.362337093
RN2_t4 N2__t4 N2 374.421195754
RN2_t5 N2__t5 N2 225.570429521
RN2_t6 N2__t6 N2 198.053465004
CN2 N2 VSS 5.5687914e-14
RNA_t0 NA__t0 NA 177.9098074
RNA_t1 NA__t1 NA 299.987016677
RNA_t2 NA__t2 NA 782.211458547
RNA_t3 NA__t3 NA 91.0640100894
RNA_t4 NA__t4 NA 432.588253149
RNA_t5 NA__t5 NA 389.407654138
CNA NA VSS 7.726204e-14
RNB_t0 NB__t0 NB 875.385865849
RNB_t1 NB__t1 NB 134.537436555
RNB_t2 NB__t2 NB 66.6687788692
RNB_t3 NB__t3 NB 481.341493586
RNB_t4 NB__t4 NB 509.685725141
CNB NB VSS 4.7120272e-14
RNBG_t0 NBG__t0 NBG 319.655393327
RNBG_t1 NBG__t1 NBG 74.3376726087
RNBG_t2 NBG__t2 NBG 180.635494451
RNBG_t3 NBG__t3 NBG 497.957181646
RNBG_t4 NBG__t4 NBG 72.3456579667
CNBG NBG VSS 2.6929172e-14
RNC_t0 NC__t0 NC 58.0128241616
RNC_t1 NC__t1 NC 5.17314575229
RNC_t2 NC__t2 NC 12.3918471968
RNC_t3 NC__t3 NC 2.88062399517
RNC_t4 NC__t4 NC 11.6230131453
RNC_t5 NC__t5 NC 5.29674321447
RNC_t6 NC__t6 NC 8.50548296342
RNC_t7 NC__t7 NC 12.4439514887
RNC_t8 NC__t8 NC 8.42906808227
CNC NC VSS 1.06239997e-13
RND_t0 ND__t0 ND 229.124892636
RND_t1 ND__t1 ND 219.61306336
RND_t2 ND__t2 ND 685.527951368
RND_t3 ND__t3 ND 378.405592635
CND ND VSS 3.4731319e-14
RNR_t0 NR__t0 NR 356.720721034
RNR_t1 NR__t1 NR 764.350678615
RNR_t2 NR__t2 NR 286.922700175
RNR_t3 NR__t3 NR 286.922700175
CNR NR VSS 3.5361036e-14
RNT_t0 NT__t0 NT 330.085678635
RNT_t1 NT__t1 NT 330.085678635
RNT_t2 NT__t2 NT 330.085678635
RNT_t3 NT__t3 NT 330.085678635
RNT_t4 NT__t4 NT 97.5193258677
RNT_t5 NT__t5 NT 264.703412634
RNT_t6 NT__t6 NT 24.5247259175
RNT_t7 NT__t7 NT 71.0974037861
RNT_t8 NT__t8 NT 134.599552202
RNT_t9 NT__t9 NT 199.46944143
RNT_t10 NT__t10 NT 24.5247259175
RNT_t11 NT__t11 NT 24.5247259175
RNT_t12 NT__t12 NT 264.703412634
RNT_t13 NT__t13 NT 24.5247259175
RNT_t14 NT__t14 NT 71.0974037861
RNT_t15 NT__t15 NT 134.599552202
RNT_t16 NT__t16 NT 199.46944143
RNT_t17 NT__t17 NT 2593.74803582
CNT NT VSS 8.5988494e-14
RNZ_t0 NZ__t0 NZ 59.5605
RNZ_t1 NZ__t1 NZ 59.5605
CNZ NZ VSS 3.4541994e-14
RPB_t0 PB__t0 PB 1632.9207003
RPB_t1 PB__t1 PB 118.157609212
RPB_t2 PB__t2 PB 645.862714873
RPB_t3 PB__t3 PB 328.441785264
RPB_t4 PB__t4 PB 328.441785264
RPB_t5 PB__t5 PB 481.85070509
CPB PB VSS 4.7116177e-14
RPCAS_t0 PCAS__t0 PCAS 810.502975562
RPCAS_t1 PCAS__t1 PCAS 648.949250633
RPCAS_t2 PCAS__t2 PCAS 758.177517915
RPCAS_t3 PCAS__t3 PCAS 758.177517915
RPCAS_t4 PCAS__t4 PCAS 218.391841544
RPCAS_t5 PCAS__t5 PCAS 101.088066233
RPCAS_t6 PCAS__t6 PCAS 345.683006763
RPCAS_t7 PCAS__t7 PCAS 389.130532764
RPCAS_t8 PCAS__t8 PCAS 518.763990671
CPCAS PCAS VSS 5.3717376e-14
RPG_t0 PG__t0 PG 334.099181493
RPG_t1 PG__t1 PG 666.150692096
RPG_t2 PG__t2 PG 83.6375011211
RPG_t3 PG__t3 PG 629.340446714
RPG_t4 PG__t4 PG 731.227109932
RPG_t5 PG__t5 PG 417.439404629
RPG_t6 PG__t6 PG 151.271388757
RPG_t7 PG__t7 PG 234.368666133
RPG_t8 PG__t8 PG 318.177485975
RPG_t9 PG__t9 PG 599.142193276
RPG_t10 PG__t10 PG 430.615978181
RPG_t11 PG__t11 PG 514.848951694
CPG PG VSS 6.8097327e-14
RPTAT_t0 PTAT__t0 PTAT 160.800719866
RPTAT_t1 PTAT__t1 PTAT 375.388079927
RPTAT_t2 PTAT__t2 PTAT 213.257920424
RPTAT_t3 PTAT__t3 PTAT 221.189879783
CPTAT PTAT VSS 4.2434413e-14
RT0_t0 T0__t0 T0 320.043026094
RT0_t1 T0__t1 T0 313.559674231
RT0_t2 T0__t2 T0 312.817780188
RT0_t3 T0__t3 T0 320.719719486
CT0 T0 VSS 6.0943107e-14
RT1_t0 T1__t0 T1 309.075824733
RT1_t1 T1__t1 T1 305.716375402
RT1_t2 T1__t2 T1 315.094088938
RT1_t3 T1__t3 T1 299.558010926
CT1 T1 VSS 6.0274424e-14
RT2_t0 T2__t0 T2 296.459639641
RT2_t1 T2__t1 T2 299.620848801
RT2_t2 T2__t2 T2 286.687901974
RT2_t3 T2__t3 T2 308.985109584
CT2 T2 VSS 5.9605742e-14
RT3_t0 T3__t0 T3 280.061751539
RT3_t1 T3__t1 T3 297.643350284
RT3_t2 T3__t2 T3 301.967758756
RT3_t3 T3__t3 T3 274.39563942
CT3 T3 VSS 5.8937059e-14
RT4_t0 T4__t0 T4 292.687741783
RT4_t1 T4__t1 T4 256.490260142
RT4_t2 T4__t2 T4 303.654865819
RT4_t3 T4__t3 T4 263.556832256
CT4 T4 VSS 5.8268377e-14
RT5_t0 T5__t0 T5 311.783920291
RT5_t1 T5__t1 T5 160.212156364
RT5_t2 T5__t2 T5 151.573623345
CT5 T5 VSS 5.1212691e-14
RVDD_t0 VDD__t0 VDD 739.787329362
RVDD_t1 VDD__t1 VDD 764.699816758
RVDD_t2 VDD__t2 VDD 764.699816758
RVDD_t3 VDD__t3 VDD 352.066842898
RVDD_t4 VDD__t4 VDD 352.066842898
RVDD_t5 VDD__t5 VDD 352.066842898
RVDD_t6 VDD__t6 VDD 352.066842898
RVDD_t7 VDD__t7 VDD 286.184231085
RVDD_t8 VDD__t8 VDD 127.399093774
RVDD_t9 VDD__t9 VDD 127.399093774
RVDD_t10 VDD__t10 VDD 320.452608218
RVDD_t11 VDD__t11 VDD 320.452608218
RVDD_t12 VDD__t12 VDD 359.530019215
RVDD_t13 VDD__t13 VDD 359.530019215
RVDD_t14 VDD__t14 VDD 508.877745899
RVDD_t15 VDD__t15 VDD 508.877745899
RVDD_t16 VDD__t16 VDD 576.92811771
RVDD_t17 VDD__t17 VDD 576.92811771
RVDD_t18 VDD__t18 VDD 414.66400553
RVDD_t19 VDD__t19 VDD 414.66400553
RVDD_t20 VDD__t20 VDD 246.418709331
RVDD_t21 VDD__t21 VDD 246.418709331
RVDD_t22 VDD__t22 VDD 97.21837953
RVDD_t23 VDD__t23 VDD 40.7447657438
RVDD_t24 VDD__t24 VDD 153.824561687
RVDD_t25 VDD__t25 VDD 172.905409255
RVDD_t26 VDD__t26 VDD 229.541270357
RVDD_t27 VDD__t27 VDD 13.1048329979
RVDD_t28 VDD__t28 VDD 68.9446262762
RVDD_t29 VDD__t29 VDD 125.516100217
RVDD_t30 VDD__t30 VDD 314.507175097
RVDD_t31 VDD__t31 VDD 201.222077662
RVDD_t32 VDD__t32 VDD 257.862155666
RVDD_t33 VDD__t33 VDD 25.9443281711
RVDD_t34 VDD__t34 VDD 25.9443281711
RVDD_t35 VDD__t35 VDD 25.9443281711
RVDD_t36 VDD__t36 VDD 13.1048329979
RVDD_t37 VDD__t37 VDD 68.9446262762
RVDD_t38 VDD__t38 VDD 125.516100217
RVDD_t39 VDD__t39 VDD 314.507175097
RVDD_t40 VDD__t40 VDD 201.222077662
RVDD_t41 VDD__t41 VDD 257.862155666
RVDD_t42 VDD__t42 VDD 25.9443281711
CVDD VDD VSS 1.61974922e-13
RVSS_t0 VSS__t0 VSS 36.5363204952
RVSS_t1 VSS__t1 VSS 39.2222969318
RVSS_t2 VSS__t2 VSS 41.9115751444
RVSS_t3 VSS__t3 VSS 37.0191709143
RVSS_t4 VSS__t4 VSS 39.6724700071
RVSS_t5 VSS__t5 VSS 42.3331599451
RVSS_t6 VSS__t6 VSS 37.6913916993
RVSS_t7 VSS__t7 VSS 40.3004574355
RVSS_t8 VSS__t8 VSS 42.9222369406
RVSS_t9 VSS__t9 VSS 7.80361734452
RVSS_t10 VSS__t10 VSS 7.66128733675
RVSS_t11 VSS__t11 VSS 7.15729615731
RVSS_t12 VSS__t12 VSS 7.09762573854
RVSS_t13 VSS__t13 VSS 11.3919468504
RVSS_t14 VSS__t14 VSS 11.4138678251
RVSS_t15 VSS__t15 VSS 11.4652329168
RVSS_t16 VSS__t16 VSS 11.545649153
RVSS_t17 VSS__t17 VSS 11.6545151901
RVSS_t18 VSS__t18 VSS 11.7910430281
RVSS_t19 VSS__t19 VSS 11.9542849425
RVSS_t20 VSS__t20 VSS 12.1431636201
RVSS_t21 VSS__t21 VSS 12.3565034838
RVSS_t22 VSS__t22 VSS 12.5930613993
RVSS_t23 VSS__t23 VSS 13.763005714
RVSS_t24 VSS__t24 VSS 14.0240103462
RVSS_t25 VSS__t25 VSS 14.3038689703
RVSS_t26 VSS__t26 VSS 14.6014975352
RVSS_t27 VSS__t27 VSS 14.9158323416
RVSS_t28 VSS__t28 VSS 15.2458400896
RVSS_t29 VSS__t29 VSS 15.5905255542
RVSS_t30 VSS__t30 VSS 15.9489371275
RVSS_t31 VSS__t31 VSS 16.3201705064
RVSS_t32 VSS__t32 VSS 16.7033708167
RVSS_t33 VSS__t33 VSS 17.0977334564
RVSS_t34 VSS__t34 VSS 17.5025039201
RVSS_t35 VSS__t35 VSS 17.9169768383
RVSS_t36 VSS__t36 VSS 18.3404944316
RVSS_t37 VSS__t37 VSS 18.7724445502
RVSS_t38 VSS__t38 VSS 19.2122584359
RVSS_t39 VSS__t39 VSS 19.6594083188
RVSS_t40 VSS__t40 VSS 20.1134049357
RVSS_t41 VSS__t41 VSS 20.5737950362
RVSS_t42 VSS__t42 VSS 21.0401589275
RVSS_t43 VSS__t43 VSS 21.5121080934
RVSS_t44 VSS__t44 VSS 21.9892829117
RVSS_t45 VSS__t45 VSS 22.4713504878
RVSS_t46 VSS__t46 VSS 22.9580026121
RVSS_t47 VSS__t47 VSS 23.6735572522
RVSS_t48 VSS__t48 VSS 24.1639427042
RVSS_t49 VSS__t49 VSS 22.2742268278
RVSS_t50 VSS__t50 VSS 22.8243404649
RVSS_t51 VSS__t51 VSS 22.6661782276
RVSS_t52 VSS__t52 VSS 23.2360817517
RVSS_t53 VSS__t53 VSS 23.5844169099
RVSS_t54 VSS__t54 VSS 24.160610579
RVSS_t55 VSS__t55 VSS 24.6598771817
RVSS_t56 VSS__t56 VSS 25.2382734756
RVSS_t57 VSS__t57 VSS 25.7869813343
RVSS_t58 VSS__t58 VSS 26.3662631898
RVSS_t59 VSS__t59 VSS 53.1842664684
RVSS_t60 VSS__t60 VSS 51.2709872655
RVSS_t61 VSS__t61 VSS 49.3610755925
RVSS_t62 VSS__t62 VSS 47.4549380486
RVSS_t63 VSS__t63 VSS 45.5530484141
RVSS_t64 VSS__t64 VSS 43.6559618782
RVSS_t65 VSS__t65 VSS 29.5043770479
RVSS_t66 VSS__t66 VSS 27.0007057354
RVSS_t67 VSS__t67 VSS 25.3626092366
RVSS_t68 VSS__t68 VSS 23.5933572026
RVSS_t69 VSS__t69 VSS 26.3289624881
RVSS_t70 VSS__t70 VSS 25.8695541719
RVSS_t71 VSS__t71 VSS 16.0665599544
RVSS_t72 VSS__t72 VSS 20.7345291374
RVSS_t73 VSS__t73 VSS 18.598332415
RVSS_t74 VSS__t74 VSS 16.5566009468
RVSS_t75 VSS__t75 VSS 18.1476676088
RVSS_t76 VSS__t76 VSS 15.227093608
RVSS_t77 VSS__t77 VSS 14.801636684
RVSS_t78 VSS__t78 VSS 14.4601010067
RVSS_t79 VSS__t79 VSS 14.0627397112
RVSS_t80 VSS__t80 VSS 16.0788157762
RVSS_t81 VSS__t81 VSS 15.8156384103
RVSS_t82 VSS__t82 VSS 15.5643090512
RVSS_t83 VSS__t83 VSS 15.3254106148
RVSS_t84 VSS__t84 VSS 15.0995331432
RVSS_t85 VSS__t85 VSS 14.8872693309
RVSS_t86 VSS__t86 VSS 53.1842664684
RVSS_t87 VSS__t87 VSS 53.1842664684
RVSS_t88 VSS__t88 VSS 53.1842664684
RVSS_t89 VSS__t89 VSS 29.5043770479
RVSS_t90 VSS__t90 VSS 27.0007057354
RVSS_t91 VSS__t91 VSS 18.1476676088
RVSS_t92 VSS__t92 VSS 25.8695541719
RVSS_t93 VSS__t93 VSS 20.7345291374
RVSS_t94 VSS__t94 VSS 18.598332415
RVSS_t95 VSS__t95 VSS 15.227093608
RVSS_t96 VSS__t96 VSS 14.4601010067
RVSS_t97 VSS__t97 VSS 36.5363204952
RVSS_t98 VSS__t98 VSS 41.9115751444
RVSS_t99 VSS__t99 VSS 37.0191709143
RVSS_t100 VSS__t100 VSS 39.6724700071
RVSS_t101 VSS__t101 VSS 42.3331599451
RVSS_t102 VSS__t102 VSS 37.6913916993
RVSS_t103 VSS__t103 VSS 40.3004574355
RVSS_t104 VSS__t104 VSS 42.9222369406
RVSS_t105 VSS__t105 VSS 39.2222969318
RVSS_t106 VSS__t106 VSS 26.3662631898
RVSS_t107 VSS__t107 VSS 14.0627397112
RVSS_t108 VSS__t108 VSS 14.801636684
RVSS_t109 VSS__t109 VSS 16.5566009468
RVSS_t110 VSS__t110 VSS 16.0665599544
RVSS_t111 VSS__t111 VSS 23.5933572026
RVSS_t112 VSS__t112 VSS 25.3626092366
RVSS_t113 VSS__t113 VSS 43.6559618782
RVSS_t114 VSS__t114 VSS 43.6559618782
RVSS_t115 VSS__t115 VSS 49.3610755925
RVSS_t116 VSS__t116 VSS 47.4549380486
RVSS_t117 VSS__t117 VSS 45.5530484141
RVSS_t118 VSS__t118 VSS 43.6559618782
RVSS_t119 VSS__t119 VSS 51.2709872655
RVSS_t120 VSS__t120 VSS 15.3254106148
RVSS_t121 VSS__t121 VSS 15.8156384103
RVSS_t122 VSS__t122 VSS 15.5643090512
RVSS_t123 VSS__t123 VSS 15.3254106148
RVSS_t124 VSS__t124 VSS 15.0995331432
RVSS_t125 VSS__t125 VSS 14.8872693309
CVSS VSS VSS 2.09783916e-13
Ccc_CTAT_NA CTAT NA 8.311e-18
Ccc_CTAT_NB CTAT NB 8.311e-18
Ccc_CTAT_NC CTAT NC 8.311e-18
Ccc_CTAT_NT CTAT NT 8.311e-18
Ccc_CTAT_NZ CTAT NZ 8.311e-18
Ccc_CTAT_PTAT CTAT PTAT 8.311e-18
Ccc_CTAT_T0 CTAT T0 8.311e-18
Ccc_CTAT_T1 CTAT T1 8.311e-18
Ccc_CTAT_T2 CTAT T2 8.311e-18
Ccc_CTAT_T3 CTAT T3 8.311e-18
Ccc_CTAT_T4 CTAT T4 8.311e-18
Ccc_CTAT_T5 CTAT T5 8.311e-18
Ccc_CTAT_VDD CTAT VDD 7.4799e-17
Ccc_EN_VDD EN VDD 7.4799e-17
Ccc_ENB_VDD ENB VDD 7.4799e-17
Ccc_IBIAS_VDD IBIAS VDD 2.4933e-17
Ccc_M1D_NT M1D NT 8.311e-18
Ccc_M1D_VDD M1D VDD 1.6622e-17
Ccc_M2D_NT M2D NT 8.311e-18
Ccc_M2D_VDD M2D VDD 1.6622e-17
Ccc_M3D_NT M3D NT 8.311e-18
Ccc_M3D_VDD M3D VDD 1.6622e-17
Ccc_N1_NT N1 NT 8.311e-18
Ccc_N1_VDD N1 VDD 8.311e-18
Ccc_N2_NA N2 NA 8.311e-18
Ccc_N2_NB N2 NB 8.311e-18
Ccc_N2_NC N2 NC 8.311e-18
Ccc_N2_NT N2 NT 8.311e-18
Ccc_N2_PTAT N2 PTAT 8.311e-18
Ccc_N2_T0 N2 T0 8.311e-18
Ccc_N2_T1 N2 T1 8.311e-18
Ccc_N2_T2 N2 T2 8.311e-18
Ccc_N2_T3 N2 T3 8.311e-18
Ccc_N2_T4 N2 T4 8.311e-18
Ccc_N2_T5 N2 T5 8.311e-18
Ccc_N2_VDD N2 VDD 7.4799e-17
Ccc_NA_NC NA NC 1.6622e-17
Ccc_NA_NT NA NT 8.311e-18
Ccc_NA_NZ NA NZ 8.311e-18
Ccc_NA_PTAT NA PTAT 8.311e-18
Ccc_NA_T0 NA T0 8.311e-18
Ccc_NA_T1 NA T1 8.311e-18
Ccc_NA_T2 NA T2 8.311e-18
Ccc_NA_T3 NA T3 8.311e-18
Ccc_NA_T4 NA T4 8.311e-18
Ccc_NA_T5 NA T5 8.311e-18
Ccc_NA_VDD NA VDD 7.4799e-17
Ccc_NA_VSS NA VSS 1.32976e-16
Ccc_NB_NC NB NC 8.311e-18
Ccc_NB_NT NB NT 8.311e-18
Ccc_NB_NZ NB NZ 8.311e-18
Ccc_NB_PTAT NB PTAT 8.311e-18
Ccc_NB_T0 NB T0 8.311e-18
Ccc_NB_T1 NB T1 8.311e-18
Ccc_NB_T2 NB T2 8.311e-18
Ccc_NB_T3 NB T3 8.311e-18
Ccc_NB_T4 NB T4 8.311e-18
Ccc_NB_T5 NB T5 8.311e-18
Ccc_NB_VDD NB VDD 7.4799e-17
Ccc_NBG_VDD NBG VDD 3.3244e-17
Ccc_NC_NT NC NT 8.311e-18
Ccc_NC_NZ NC NZ 8.311e-18
Ccc_NC_PTAT NC PTAT 8.311e-18
Ccc_NC_T0 NC T0 1.6622e-17
Ccc_NC_T1 NC T1 1.6622e-17
Ccc_NC_T2 NC T2 1.6622e-17
Ccc_NC_T3 NC T3 1.6622e-17
Ccc_NC_T4 NC T4 1.6622e-17
Ccc_NC_T5 NC T5 1.6622e-17
Ccc_NC_VDD NC VDD 7.4799e-17
Ccc_NC_VSS NC VSS 2.65952e-16
Ccc_ND_NT ND NT 8.311e-18
Ccc_ND_VDD ND VDD 6.6488e-17
Ccc_NR_NT NR NT 8.311e-18
Ccc_NR_VDD NR VDD 6.6488e-17
Ccc_NT_NZ NT NZ 8.311e-18
Ccc_NT_PG NT PG 8.311e-18
Ccc_NT_PTAT NT PTAT 8.311e-18
Ccc_NT_T0 NT T0 8.311e-18
Ccc_NT_T1 NT T1 8.311e-18
Ccc_NT_T2 NT T2 8.311e-18
Ccc_NT_T3 NT T3 8.311e-18
Ccc_NT_T4 NT T4 8.311e-18
Ccc_NT_T5 NT T5 8.311e-18
Ccc_NT_VDD NT VDD 7.4799e-17
Ccc_NZ_PG NZ PG 1.36745e-16
Ccc_NZ_VDD NZ VDD 7.4799e-17
Ccc_PB_VDD PB VDD 5.8177e-17
Ccc_PCAS_VDD PCAS VDD 4.1555e-17
Ccc_PG_VDD PG VDD 7.4799e-17
Ccc_PTAT_T0 PTAT T0 8.311e-18
Ccc_PTAT_T1 PTAT T1 8.311e-18
Ccc_PTAT_T2 PTAT T2 8.311e-18
Ccc_PTAT_T3 PTAT T3 8.311e-18
Ccc_PTAT_T4 PTAT T4 8.311e-18
Ccc_PTAT_T5 PTAT T5 8.311e-18
Ccc_PTAT_VDD PTAT VDD 7.4799e-17
Ccc_T0_T1 T0 T1 1.6622e-17
Ccc_T0_T2 T0 T2 1.6622e-17
Ccc_T0_T3 T0 T3 1.6622e-17
Ccc_T0_T4 T0 T4 1.6622e-17
Ccc_T0_T5 T0 T5 1.6622e-17
Ccc_T0_VDD T0 VDD 7.4799e-17
Ccc_T1_T2 T1 T2 1.6622e-17
Ccc_T1_T3 T1 T3 1.6622e-17
Ccc_T1_T4 T1 T4 1.6622e-17
Ccc_T1_T5 T1 T5 1.6622e-17
Ccc_T1_VDD T1 VDD 7.4799e-17
Ccc_T2_T3 T2 T3 1.6622e-17
Ccc_T2_T4 T2 T4 1.6622e-17
Ccc_T2_T5 T2 T5 1.6622e-17
Ccc_T2_VDD T2 VDD 7.4799e-17
Ccc_T3_T4 T3 T4 1.6622e-17
Ccc_T3_T5 T3 T5 1.6622e-17
Ccc_T3_VDD T3 VDD 7.4799e-17
Ccc_T4_T5 T4 T5 1.6622e-17
Ccc_T4_VDD T4 VDD 7.4799e-17
Ccc_T5_VDD T5 VDD 7.4799e-17
Rvsubs_dctie VSS 0 1e+12
.ends temp_core

* por_comparator -- post-layout netlist
* GENERATED by layout/postlayout.py -- do not edit.
*
* FROM THE LAYOUT: every device and its dimensions, the whole
*   topology, and first-order interconnect R/C on 15/15 nets
*   (sigma 526.8 fF, of which 0.057 fF is net-to-net coupling).
*   One star per net: <net> is the hub, <net>__t<k> each device
*   terminal on it, R<net>_t<k> the arm between them.
*   klt 0.6.0, deck gf180mcu,
*   GDS sha256 e6e5601250e6c78e...
* Net names are the schematic's, restored through klt lvs's own net
*   correspondence -- match, 15/15 nets, every one paired.
*
* NOT FROM THE LAYOUT -- see layout/postlayout/AUDIT.md:
*   3 body/plate net(s) tied to the net the schematic puts
*   them on. The extraction deck's connectivity stack does not reach
*   an Nwell, a substrate ring, a bipolar base well or a MiM plate,
*   so they extract isolated and would otherwise float.
*   No ideal device: every golden device is drawn.
*
.subckt por_comparator VDD VSS IBIAS VREF BIAS_OK POR_RAW

* --- drawn devices ---
X1 TN__t1 NBG__t0 VSS__t2 VSS__t13 nfet_03v3 L=10u W=1u nf=1 ad=0.8p as=0.8p pd=3.6u ps=3.6u m=1
X2 IBIAS__t2 BIAS_OKB__t2 VSS__t3 VSS__t14 nfet_03v3 L=1u W=1u nf=1 ad=0.8p as=0.8p pd=3.6u ps=3.6u m=1
X3 N1__t2 CMPO__t1 VSS__t5 VSS__t15 nfet_03v3 L=0.5u W=1u nf=1 ad=0.8p as=0.8p pd=3.6u ps=3.6u m=1
X4 POR_RAW__t0 N1__t3 VSS__t7 VSS__t16 nfet_03v3 L=0.5u W=1u nf=1 ad=0.8p as=0.8p pd=3.6u ps=3.6u m=1
X5 BIAS_OKB__t4 BIAS_OK__t0 VSS__t6 VSS__t17 nfet_03v3 L=0.5u W=1u nf=1 ad=0.8p as=0.5p pd=3.6u ps=3u m=1
X6 NA__t2 SNS__t2 TN__t0 VSS__t18 nfet_03v3 L=1u W=2u nf=1 ad=1.6p as=1.6p pd=5.6u ps=5.6u m=1
X7 CMPO__t2 VREF__t0 TN__t2 VSS__t19 nfet_03v3 L=1u W=2u nf=1 ad=1.6p as=1.6p pd=5.6u ps=5.6u m=1
X8 IBIAS__t0 NBG__t1 VSS__t1 VSS__t21 nfet_03v3 L=2u W=2u nf=1 ad=1.6p as=1.6p pd=5.6u ps=5.6u m=1
X9 IBIAS__t1 BIAS_OK__t2 NBG__t2 VSS__t22 nfet_03v3 L=0.5u W=2u nf=1 ad=1.6p as=1.6p pd=5.6u ps=5.6u m=1
X10 NBG__t3 BIAS_OKB__t1 VSS__t8 VSS__t23 nfet_03v3 L=0.5u W=2u nf=1 ad=1.6p as=1.6p pd=5.6u ps=5.6u m=1
X11 CMPO__t3 BIAS_OKB__t3 VSS__t9 VSS__t20 nfet_03v3 L=1u W=2u nf=1 ad=1.6p as=1.6p pd=5.6u ps=5.6u m=1
X12 SNSB__t1 N1__t1 VSS__t4 VSS__t24 nfet_03v3 L=0.5u W=10u nf=1 ad=8p as=8p pd=21.6u ps=21.6u m=1
X13 N1__t0 CMPO__t0 VDD__t3 VDD__t4 pfet_03v3 L=0.5u W=2u nf=1 ad=1.6p as=1.6p pd=5.6u ps=5.6u m=1
X14 POR_RAW__t1 N1__t4 VDD__t9 VDD__t8 pfet_03v3 L=0.5u W=2u nf=1 ad=1.6p as=1.6p pd=5.6u ps=5.6u m=1
X15 NA__t0 NA__t1 VDDA__t0 VDD__t0 pfet_03v3 L=1u W=4u nf=1 ad=3.2p as=3.2p pd=9.6u ps=9.6u m=1
X16 CMPO__t4 NA__t3 VDDA__t2 VDD__t10 pfet_03v3 L=1u W=4u nf=1 ad=3.2p as=3.2p pd=9.6u ps=9.6u m=1
X17 VDDA__t1 BIAS_OKB__t0 VDD__t1 VDD__t2 pfet_03v3 L=0.5u W=4u nf=1 ad=3.2p as=3.2p pd=9.6u ps=9.6u m=1
X18 BIAS_OKB__t5 BIAS_OK__t1 VDD__t5 VDD__t6 pfet_03v3 L=0.5u W=2u nf=1 ad=1.6p as=1p pd=5.6u ps=5u m=1
X19 SNSB__t0 SNS__t1 VSS__t10 ppolyf_u_3k r_width=2u r_length=6769.23u
X20 VSS__t0 SNSB__t2 VSS__t11 ppolyf_u_3k r_width=2u r_length=775u
X21 SNS__t0 VDD__t7 VSS__t12 ppolyf_u_3k r_width=2u r_length=7897.44u

R_10_t0 SNS__t0 SNS 122.891188735
R_10_t1 SNS__t1 SNS 684.260298411
R_10_t2 SNS__t2 SNS 686.317212854
C_10 SNS VSS 5.2676745e-14
R_12_t0 NBG__t0 NBG 715.139441326
R_12_t1 NBG__t1 NBG 44.0457601943
R_12_t2 NBG__t2 NBG 257.887617601
R_12_t3 NBG__t3 NBG 499.88258088
C_12 NBG VSS 2.1326008e-14
R_14_t0 SNSB__t0 SNSB 212.505970377
R_14_t1 SNSB__t1 SNSB 688.024299088
R_14_t2 SNSB__t2 SNSB 513.046030534
C_14 SNSB VSS 4.4264354e-14
R_3_t0 VDDA__t0 VDDA 631.9122
R_3_t1 VDDA__t1 VDDA 616.937977251
R_3_t2 VDDA__t2 VDDA 14.9742227488
C_3 VDDA VSS 1.4679011e-14
R_4_t0 NA__t0 NA 288.034386996
R_4_t1 NA__t1 NA 288.034386996
R_4_t2 NA__t2 NA 692.332138375
R_4_t3 NA__t3 NA 116.445087634
C_4 NA VSS 1.5868526e-14
R_5_t0 CMPO__t0 CMPO 261.418858782
R_5_t1 CMPO__t1 CMPO 366.105615344
R_5_t2 CMPO__t2 CMPO 88.9071013133
R_5_t3 CMPO__t3 CMPO 324.899769804
R_5_t4 CMPO__t4 CMPO 340.793554757
C_5 CMPO VSS 1.7766709e-14
R_7_t0 N1__t0 N1 377.193158999
R_7_t1 N1__t1 N1 175.868361694
R_7_t2 N1__t2 N1 253.833596266
R_7_t3 N1__t3 N1 292.041043747
R_7_t4 N1__t4 N1 338.946339293
C_7 N1 VSS 1.7866109e-14
R_9_t0 TN__t0 TN 486.762381087
R_9_t1 TN__t1 TN 630.394143252
R_9_t2 TN__t2 TN 143.96957566
C_9 TN VSS 1.3588667e-14
RBIAS_OK_t0 BIAS_OK__t0 BIAS_OK 363.218515086
RBIAS_OK_t1 BIAS_OK__t1 BIAS_OK 369.383580086
RBIAS_OK_t2 BIAS_OK__t2 BIAS_OK 719.565404828
CBIAS_OK BIAS_OK VSS 1.5010689e-14
RBIAS_OKB_t0 BIAS_OKB__t0 BIAS_OKB 744.308889961
RBIAS_OKB_t1 BIAS_OKB__t1 BIAS_OKB 59.9080526262
RBIAS_OKB_t2 BIAS_OKB__t2 BIAS_OKB 17.0676522536
RBIAS_OKB_t3 BIAS_OKB__t3 BIAS_OKB 109.722398109
RBIAS_OKB_t4 BIAS_OKB__t4 BIAS_OKB 349.031750011
RBIAS_OKB_t5 BIAS_OKB__t5 BIAS_OKB 351.14495704
CBIAS_OKB BIAS_OKB VSS 2.1654538e-14
RIBIAS_t0 IBIAS__t0 IBIAS 533.695252733
RIBIAS_t1 IBIAS__t1 IBIAS 99.7987141232
RIBIAS_t2 IBIAS__t2 IBIAS 632.489533144
CIBIAS IBIAS VSS 1.5551286e-14
RPOR_RAW_t0 POR_RAW__t0 POR_RAW 630.2627
RPOR_RAW_t1 POR_RAW__t1 POR_RAW 630.2627
CPOR_RAW POR_RAW VSS 1.3389027e-14
RVDD_t0 VDD__t0 VDD 5.9041895961
RVDD_t1 VDD__t1 VDD 4.71508973949
RVDD_t2 VDD__t2 VDD 4.71508973949
RVDD_t3 VDD__t3 VDD 4.24096746289
RVDD_t4 VDD__t4 VDD 4.24096746289
RVDD_t5 VDD__t5 VDD 6.87650413981
RVDD_t6 VDD__t6 VDD 6.87650413981
RVDD_t7 VDD__t7 VDD 24.3165014744
RVDD_t8 VDD__t8 VDD 3.72828176386
RVDD_t9 VDD__t9 VDD 3.72828176386
RVDD_t10 VDD__t10 VDD 5.28662271739
CVDD VDD VSS 5.2337816e-14
RVREF_t0 VREF__t0 VREF 1314.9134
CVREF VREF VSS 1.1576327e-14
RVSS_t0 VSS__t0 VSS 21.9623916049
RVSS_t1 VSS__t1 VSS 3.68926797329
RVSS_t2 VSS__t2 VSS 4.28730713656
RVSS_t3 VSS__t3 VSS 2.98646338292
RVSS_t4 VSS__t4 VSS 2.71447557922
RVSS_t5 VSS__t5 VSS 2.3015019586
RVSS_t6 VSS__t6 VSS 1.57310764032
RVSS_t7 VSS__t7 VSS 2.09215843778
RVSS_t8 VSS__t8 VSS 3.21060999989
RVSS_t9 VSS__t9 VSS 2.52186312651
RVSS_t10 VSS__t10 VSS 15.4918826332
RVSS_t11 VSS__t11 VSS 21.9623916049
RVSS_t12 VSS__t12 VSS 6.28602125058
RVSS_t13 VSS__t13 VSS 4.28730713656
RVSS_t14 VSS__t14 VSS 2.98646338292
RVSS_t15 VSS__t15 VSS 2.3015019586
RVSS_t16 VSS__t16 VSS 2.09215843778
RVSS_t17 VSS__t17 VSS 1.57310764032
RVSS_t18 VSS__t18 VSS 5.09283406728
RVSS_t19 VSS__t19 VSS 4.84353174536
RVSS_t20 VSS__t20 VSS 2.52186312651
RVSS_t21 VSS__t21 VSS 3.68926797329
RVSS_t22 VSS__t22 VSS 3.42393662359
RVSS_t23 VSS__t23 VSS 3.21060999989
RVSS_t24 VSS__t24 VSS 2.71447557922
CVSS VSS VSS 1.99238424e-13
Ccc__10__14 SNS SNSB 1.8889e-17
Ccc__10_BIAS_OK SNS BIAS_OK 9.444e-18
Ccc__10_BIAS_OKB SNS BIAS_OKB 9.444e-18
Ccc__10_VDD SNS VDD 9.444e-18
Ccc__14_VDD SNSB VDD 9.444e-18
Rvsubs_dctie VSS 0 1e+12
.ends por_comparator

* por_output_chain -- post-layout netlist
* GENERATED by layout/postlayout.py -- do not edit.
*
* FROM THE LAYOUT: every device and its dimensions, the whole
*   topology, and first-order interconnect R/C on 18/18 nets
*   (sigma 901.4 fF, of which 81.195 fF is net-to-net coupling).
*   One star per net: <net> is the hub, <net>__t<k> each device
*   terminal on it, R<net>_t<k> the arm between them.
*   klt 0.6.0, deck gf180mcu,
*   GDS sha256 79a1439bdf87109c...
* Net names are the schematic's, restored through klt lvs's own net
*   correspondence -- match, 18/18 nets, every one paired.
*
* NOT FROM THE LAYOUT -- see layout/postlayout/AUDIT.md:
*   2 body/plate net(s) tied to the net the schematic puts
*   them on. The extraction deck's connectivity stack does not reach
*   an Nwell, a substrate ring, a bipolar base well or a MiM plate,
*   so they extract isolated and would otherwise float.
*   No ideal device: every golden device is drawn.
*
.subckt por_output_chain VDD VSS IBIAS POR_RAW RESETn

* --- drawn devices ---
X1 PDN__t0 IBIAS__t0 VSS__t0 VSS__t17 nfet_03v3 L=25u W=0.5u nf=1 ad=0.4p as=0.4p pd=2.6u ps=2.6u m=1
X2 PGDGB__t2 PGDG__t3 VSS__t1 VSS__t18 nfet_03v3 L=2u W=0.5u nf=1 ad=0.4p as=0.4p pd=2.6u ps=2.6u m=1
X3 ND1__t1 NDL__t0 VSS__t2 VSS__t19 nfet_03v3 L=10u W=0.5u nf=1 ad=0.4p as=0.4p pd=2.6u ps=2.6u m=1
X4 NDG__t2 POR_RAW__t1 NDGN__t0 VSS__t20 nfet_03v3 L=0.5u W=1u nf=1 ad=0.8p as=0.8p pd=3.6u ps=3.6u m=1
X5 TIM__t4 PGDGB__t3 VSS__t3 VSS__t21 nfet_03v3 L=1u W=1u nf=1 ad=0.8p as=0.8p pd=3.6u ps=3.6u m=1
X6 TRIP__t3 ND1__t3 VSS__t16 VSS__t22 nfet_03v3 L=1u W=1u nf=1 ad=0.8p as=0.8p pd=3.6u ps=3.6u m=1
X7 ND1__t2 RESETn__t2 VSS__t15 VSS__t23 nfet_03v3 L=1u W=1u nf=1 ad=0.8p as=0.8p pd=3.6u ps=3.6u m=1
X8 NDL__t1 NDL__t2 VSS__t4 VSS__t24 nfet_03v3 L=10u W=2u nf=1 ad=1.6p as=1.6p pd=5.6u ps=5.6u m=1
X9 PGDG__t4 NDG__t3 VSS__t5 VSS__t25 nfet_03v3 L=0.5u W=2u nf=1 ad=1.6p as=1.6p pd=5.6u ps=5.6u m=1
X10 RSTB__t4 TRIP__t1 NNAND__t1 VSS__t26 nfet_03v3 L=0.5u W=2u nf=1 ad=1.6p as=1.6p pd=5.6u ps=5.6u m=1
X11 NNAND__t0 PGDG__t5 VSS__t14 VSS__t27 nfet_03v3 L=0.5u W=2u nf=1 ad=1.6p as=1.6p pd=5.6u ps=5.6u m=1
X12 IBIAS__t1 IBIAS__t2 VSS__t6 VSS__t28 nfet_03v3 L=4u W=4u nf=1 ad=3.2p as=3.2p pd=9.6u ps=9.6u m=1
X13 NDGN__t1 NDL__t3 VSS__t7 VSS__t29 nfet_03v3 L=10u W=10u nf=1 ad=8p as=8p pd=21.6u ps=21.6u m=1
X14 RESETn__t0 RSTB__t0 VSS__t8 VSS__t30 nfet_03v3 L=0.5u W=10u nf=1 ad=8p as=8p pd=21.6u ps=21.6u m=1
X15 NTS__t0 PDN__t1 VDD__t0 VDD__t1 pfet_03v3 L=10u W=0.5u nf=1 ad=0.4p as=0.4p pd=2.6u ps=2.6u m=1
X16 TRIP__t2 PDN__t6 VDD__t25 VDD__t23 pfet_03v3 L=10u W=0.5u nf=1 ad=0.4p as=0.4p pd=2.6u ps=2.6u m=1
X17 PGDG__t0 NDG__t0 VDD__t2 VDD__t3 pfet_03v3 L=2u W=0.5u nf=1 ad=0.4p as=0.4p pd=2.6u ps=2.6u m=1
X18 RSTB__t5 RESETn__t3 VDD__t24 VDD__t22 pfet_03v3 L=10u W=0.5u nf=1 ad=0.4p as=0.4p pd=2.6u ps=2.6u m=1
X19 NDG__t1 POR_RAW__t0 NDGP__t0 VDD__t4 pfet_03v3 L=0.5u W=1u nf=1 ad=0.8p as=0.8p pd=3.6u ps=3.6u m=1
X20 RESETn__t1 RSTB__t1 VDD__t5 VDD__t6 pfet_03v3 L=1u W=1u nf=1 ad=0.8p as=0.8p pd=3.6u ps=3.6u m=1
X21 PDN__t2 PDN__t3 VDD__t7 VDD__t8 pfet_03v3 L=10u W=2u nf=1 ad=1.6p as=1.6p pd=5.6u ps=5.6u m=1
X22 NDL__t4 PDN__t5 VDD__t21 VDD__t20 pfet_03v3 L=10u W=2u nf=1 ad=1.6p as=1.6p pd=5.6u ps=5.6u m=1
X23 PGDGB__t0 PGDG__t1 VDD__t9 VDD__t10 pfet_03v3 L=0.5u W=2u nf=1 ad=1.6p as=1.6p pd=5.6u ps=5.6u m=1
X24 TIM__t5 PGDGB__t1 NTS__t1 VDD__t11 pfet_03v3 L=1u W=2u nf=1 ad=1.6p as=1.6p pd=5.6u ps=5.6u m=1
X25 ND1__t0 TIM__t6 VDD__t12 VDD__t19 pfet_03v3 L=1u W=2u nf=1 ad=1.6p as=1.6p pd=5.6u ps=5.6u m=1
X26 RSTB__t2 TRIP__t0 VDD__t13 VDD__t14 pfet_03v3 L=0.5u W=4u nf=1 ad=3.2p as=3.2p pd=9.6u ps=9.6u m=1
X27 RSTB__t3 PGDG__t2 VDD__t18 VDD__t17 pfet_03v3 L=0.5u W=4u nf=1 ad=3.2p as=3.2p pd=9.6u ps=9.6u m=1
X28 NDGP__t1 PDN__t4 VDD__t15 VDD__t16 pfet_03v3 L=10u W=10u nf=1 ad=8p as=8p pd=21.6u ps=21.6u m=1
X29 NDG__t4 VSS__t9 cap_mim_2f0_m3m4_noshield c_width=11u c_length=11u
X30 TIM__t0 VSS__t10 cap_mim_2f0_m3m4_noshield c_width=28u c_length=28u
X31 TIM__t3 VSS__t13 cap_mim_2f0_m3m4_noshield c_width=28u c_length=28u
X32 TIM__t2 VSS__t12 cap_mim_2f0_m3m4_noshield c_width=28u c_length=28u
X33 TIM__t1 VSS__t11 cap_mim_2f0_m3m4_noshield c_width=28u c_length=28u

R_10_t0 NDGN__t0 NDGN 1968.54035
R_10_t1 NDGN__t1 NDGN 1968.54035
C_10 NDGN VSS 3.4262384e-14
R_11_t0 NDG__t0 NDG 1014.07506597
R_11_t1 NDG__t1 NDG 954.603905263
R_11_t2 NDG__t2 NDG 719.797860447
R_11_t3 NDG__t3 NDG 671.322091399
R_11_t4 NDG__t4 NDG 740.648776922
C_11 NDG VSS 5.2682676e-14
R_12_t0 PGDG__t0 PGDG 602.446318769
R_12_t1 PGDG__t1 PGDG 654.828626133
R_12_t2 PGDG__t2 PGDG 837.510194981
R_12_t3 PGDG__t3 PGDG 818.584937735
R_12_t4 PGDG__t4 PGDG 870.985079265
R_12_t5 PGDG__t5 PGDG 405.068343117
C_12 PGDG VSS 4.2322747e-14
R_13_t0 TIM__t0 TIM 550.192925008
R_13_t1 TIM__t1 TIM 450.44845788
R_13_t2 TIM__t2 TIM 646.825671411
R_13_t3 TIM__t3 TIM 295.351686536
R_13_t4 TIM__t4 TIM 305.553184754
R_13_t5 TIM__t5 TIM 892.679198138
R_13_t6 TIM__t6 TIM 921.604176272
C_13 TIM VSS 8.4756315e-14
R_14_t0 TRIP__t0 TRIP 1336.10142733
R_14_t1 TRIP__t1 TRIP 928.634222318
R_14_t2 TRIP__t2 TRIP 694.201632009
R_14_t3 TRIP__t3 TRIP 1101.25331834
C_14 TRIP VSS 3.9432796e-14
R_15_t0 NNAND__t0 NNAND 1969.9799
R_15_t1 NNAND__t1 NNAND 1969.9799
C_15 NNAND VSS 3.5401418e-14
R_16_t0 NDGP__t0 NDGP 1968.36045
R_16_t1 NDGP__t1 NDGP 1968.36045
C_16 NDGP VSS 3.4117005e-14
R_17_t0 RSTB__t0 RSTB 754.19830579
R_17_t1 RSTB__t1 RSTB 577.101205748
R_17_t2 RSTB__t2 RSTB 125.223191397
R_17_t3 RSTB__t3 RSTB 198.604997756
R_17_t4 RSTB__t4 RSTB 2034.86326663
R_17_t5 RSTB__t5 RSTB 386.186232677
C_17 RSTB VSS 4.4183369e-14
R_2_t0 PDN__t0 PDN 2192.18513758
R_2_t1 PDN__t1 PDN 753.814003433
R_2_t2 PDN__t2 PDN 119.940253161
R_2_t3 PDN__t3 PDN 119.940253161
R_2_t4 PDN__t4 PDN 470.418947224
R_2_t5 PDN__t5 PDN 171.383237922
R_2_t6 PDN__t6 PDN 1044.80236751
C_2 PDN VSS 5.6528747e-14
R_3_t0 NDL__t0 NDL 418.160636306
R_3_t1 NDL__t1 NDL 878.61286536
R_3_t2 NDL__t2 NDL 878.61286536
R_3_t3 NDL__t3 NDL 479.294941313
R_3_t4 NDL__t4 NDL 1807.81299166
C_3 NDL VSS 4.7374149e-14
R_5_t0 PGDGB__t0 PGDGB 985.115471459
R_5_t1 PGDGB__t1 PGDGB 1048.31915217
R_5_t2 PGDGB__t2 PGDGB 1055.41000903
R_5_t3 PGDGB__t3 PGDGB 978.029067333
C_5 PGDGB VSS 3.8921287e-14
R_6_t0 ND1__t0 ND1 2004.66951985
R_6_t1 ND1__t1 ND1 851.440640246
R_6_t2 ND1__t2 ND1 526.661303231
R_6_t3 ND1__t3 ND1 626.580236676
C_6 ND1 VSS 3.9492693e-14
R_8_t0 NTS__t0 NTS 1969.2657
R_8_t1 NTS__t1 NTS 1969.2657
C_8 NTS VSS 3.4836444e-14
RIBIAS_t0 IBIAS__t0 IBIAS 2199.33055
RIBIAS_t1 IBIAS__t1 IBIAS 1099.665275
RIBIAS_t2 IBIAS__t2 IBIAS 1099.665275
CIBIAS IBIAS VSS 4.5280553e-14
RPOR_RAW_t0 POR_RAW__t0 POR_RAW 2023.6421
RPOR_RAW_t1 POR_RAW__t1 POR_RAW 2023.6421
CPOR_RAW POR_RAW VSS 3.435215e-14
RRESETn_t0 RESETn__t0 RESETn 883.591221836
RRESETn_t1 RESETn__t1 RESETn 700.167162863
RRESETn_t2 RESETn__t2 RESETn 2080.85833879
RRESETn_t3 RESETn__t3 RESETn 502.463076507
CRESETn RESETn VSS 4.4258787e-14
RVDD_t0 VDD__t0 VDD 2.35999148776
RVDD_t1 VDD__t1 VDD 2.35999148776
RVDD_t2 VDD__t2 VDD 0.788098333131
RVDD_t3 VDD__t3 VDD 0.788098333131
RVDD_t4 VDD__t4 VDD 0.295249720716
RVDD_t5 VDD__t5 VDD 5.06439905244
RVDD_t6 VDD__t6 VDD 5.06439905244
RVDD_t7 VDD__t7 VDD 7.23527963295
RVDD_t8 VDD__t8 VDD 7.23527963295
RVDD_t9 VDD__t9 VDD 1.2760983336
RVDD_t10 VDD__t10 VDD 1.2760983336
RVDD_t11 VDD__t11 VDD 1.70838162397
RVDD_t12 VDD__t12 VDD 2.17294680535
RVDD_t13 VDD__t13 VDD 2.60734965526
RVDD_t14 VDD__t14 VDD 2.60734965526
RVDD_t15 VDD__t15 VDD 4.01357304527
RVDD_t16 VDD__t16 VDD 4.01357304527
RVDD_t17 VDD__t17 VDD 3.00712811554
RVDD_t18 VDD__t18 VDD 3.00712811554
RVDD_t19 VDD__t19 VDD 2.17294680535
RVDD_t20 VDD__t20 VDD 5.60920221824
RVDD_t21 VDD__t21 VDD 5.60920221824
RVDD_t22 VDD__t22 VDD 4.02007759857
RVDD_t23 VDD__t23 VDD 0.740540049554
RVDD_t24 VDD__t24 VDD 4.02007759857
RVDD_t25 VDD__t25 VDD 0.740540049554
CVDD VDD VSS 6.8863152e-14
RVSS_t0 VSS__t0 VSS 3.0504807567
RVSS_t1 VSS__t1 VSS 0.623413386554
RVSS_t2 VSS__t2 VSS 0.926502729824
RVSS_t3 VSS__t3 VSS 0.633889397759
RVSS_t4 VSS__t4 VSS 1.8412251982
RVSS_t5 VSS__t5 VSS 0.647622869458
RVSS_t6 VSS__t6 VSS 4.07178625969
RVSS_t7 VSS__t7 VSS 1.02751523267
RVSS_t8 VSS__t8 VSS 8.86000647857
RVSS_t9 VSS__t9 VSS 1.68526577635
RVSS_t10 VSS__t10 VSS 3.92540218501
RVSS_t11 VSS__t11 VSS 4.32044174866
RVSS_t12 VSS__t12 VSS 5.23235681228
RVSS_t13 VSS__t13 VSS 2.58794153849
RVSS_t14 VSS__t14 VSS 1.89460679736
RVSS_t15 VSS__t15 VSS 1.53287091387
RVSS_t16 VSS__t16 VSS 1.33211712448
RVSS_t17 VSS__t17 VSS 3.0504807567
RVSS_t18 VSS__t18 VSS 0.623413386554
RVSS_t19 VSS__t19 VSS 0.926502729824
RVSS_t20 VSS__t20 VSS 0.778793901586
RVSS_t21 VSS__t21 VSS 0.633889397759
RVSS_t22 VSS__t22 VSS 1.33211712448
RVSS_t23 VSS__t23 VSS 1.53287091387
RVSS_t24 VSS__t24 VSS 1.8412251982
RVSS_t25 VSS__t25 VSS 0.647622869458
RVSS_t26 VSS__t26 VSS 1.71372374734
RVSS_t27 VSS__t27 VSS 1.89460679736
RVSS_t28 VSS__t28 VSS 4.07178625969
RVSS_t29 VSS__t29 VSS 1.02751523267
RVSS_t30 VSS__t30 VSS 8.86000647857
CVSS VSS VSS 1.24338142e-13
Ccc__11__12 NDG PGDG 4.7222e-17
Ccc__11__13 NDG TIM 5.0173e-17
Ccc__11__14 NDG TRIP 4.7222e-17
Ccc__11__15 NDG NNAND 2.3611e-17
Ccc__11__17 NDG RSTB 7.0832e-17
Ccc__11__5 NDG PGDGB 4.7222e-17
Ccc__11__6 NDG ND1 4.7222e-17
Ccc__11__8 NDG NTS 2.3611e-17
Ccc__11_RESETn NDG RESETn 4.7222e-17
Ccc__11_VDD NDG VDD 1.5347e-16
Ccc__11_VSS NDG VSS 3.269281e-15
Ccc__13__14 TIM TRIP 4.7222e-17
Ccc__13__15 TIM NNAND 2.3611e-17
Ccc__13__17 TIM RSTB 7.0832e-17
Ccc__13__6 TIM ND1 4.7222e-17
Ccc__13_RESETn TIM RESETn 4.7222e-17
Ccc__13_VDD TIM VDD 1.5347e-16
Ccc__13_VSS TIM VSS 7.697882e-14
Rvsubs_dctie VSS 0 1e+12
.ends por_output_chain
