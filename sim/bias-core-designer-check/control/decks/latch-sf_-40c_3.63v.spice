* starved-window control -- bias_core.spice @ sf/-40.0 C/3.63 V
* GENERATED by sim/bias-core-designer-check/control/run_starved_window.py
* pdk=gf180mcuD@c6d73a35f524070e85faff4a6a9eef49553ebc2b  harness=0.1.0

.param vdd_nom=3.3
.param vdd_val=3.63
.param temp_c=-40.0

.include "/Users/rwalters/.volare/gf180mcuD/libs.tech/ngspice/design.ngspice"
.lib "/Users/rwalters/.volare/gf180mcuD/libs.tech/ngspice/sm141064.ngspice" sf
.lib "/Users/rwalters/.volare/gf180mcuD/libs.tech/ngspice/sm141064.ngspice" res_typical
.lib "/Users/rwalters/.volare/gf180mcuD/libs.tech/ngspice/sm141064.ngspice" bjt_typical
.lib "/Users/rwalters/.volare/gf180mcuD/libs.tech/ngspice/sm141064.ngspice" diode_typical
.lib "/Users/rwalters/.volare/gf180mcuD/libs.tech/ngspice/sm141064.ngspice" moscap_typical
.lib "/Users/rwalters/.volare/gf180mcuD/libs.tech/ngspice/sm141064.ngspice" mimcap_typical

.temp -40.0
.options reltol=1e-4
.options abstol=1e-15
.options vntol=1e-8

* Starved-window LATCH TEST -- stimulus half of the control fragment (#185).
*
* The other half is a verbatim copy of layout/postlayout/bias_core.spice,
* appended by run_starved_window.py.
*
* Netlist FRAGMENT: no .include / .lib / .temp / .control / .end -- the
* control script owns those, and reads the corner sections and solver
* tolerances from the harness and from ../testbench/tb.json rather than
* restating them.
*
* This is ../testbench/stimulus.spice's `xd` DEEP-BROWNOUT branch -- the
* replacement deck's own rail shape, not the superseded serialized one the
* sibling fragment starved_window.spice reproduces -- with exactly one
* change: the hold after the rail returns runs to `t_hold` instead of 30 ms.
*
* THE QUESTION. The replacement deck samples `bo_deep_ppm` and
* `ok_bo_end_droop_mv` at 29.9 ms and both still FAIL at the slowest corner.
* Two explanations fit that observation and they have opposite consequences
* for the cell:
*
*   (a) the reference has latched onto the DVBE loop's second, zero-current
*       solution and will never come back -- a real startup defect; or
*   (b) the recovery is simply still in progress at 29.9 ms.
*
* Only a longer run separates them, and the replacement deck deliberately
* does not do that: lengthening the graded deck until every corner goes
* green would hide the very number `t_false_ok_brownout_us` and
* `t_bo_recover_us` exist to report. So the question is asked here, once,
* off the record, at the corners that need it.
*
* `xst` is carried over from the parent deck because the reference error
* `eb` below is referred to ITS settled VREF at the same corner rather than
* to a hardcoded 1.2 V, exactly as the parent deck refers every error and
* false-valid signal.

vsupst vddst 0 dc {vdd_val}
vibst  nibst ibiasst dc 0
xst    vddst 0 nibst vrefst bias_okst bias_core
xmldst ibiasst ibiasst 0 0 nfet_03v3 L=2u W=2u nf=1 m=1

vsupb vddb 0 PWL(0 0 100u {vdd_val} 950u {vdd_val} 960u 0 1100u 0
+ 1110u {vdd_val} 120m {vdd_val})
vibb  nibb ibiasb dc 0
xb    vddb 0 nibb vrefb bias_okb bias_core
xmldb ibiasb ibiasb 0 0 nfet_03v3 L=2u W=2u nf=1 m=1
Beb  eb  0 v = abs(v(vrefb) - v(vrefst))
Bfob fob 0 v = ((v(bias_okb) > 0.5*v(vddb)) ? 1 : 0) * ((v(vrefst)-v(vrefb) > 0.1) ? 1 : 0)

* bias_core -- post-layout netlist
* GENERATED by layout/postlayout.py -- do not edit.
*
* FROM THE LAYOUT: every device and its dimensions, the whole
*   topology, and first-order interconnect R/C on 47/54 nets
*   (sigma 1920.0 fF). klt 0.2.0, deck gf180mcu,
*   GDS sha256 6d6236d05ae0cd82...
* Net names are the schematic's, restored through klt lvs's own net
*   correspondence -- match, 54/54 nets, every one paired.
*
* NOT FROM THE LAYOUT -- see layout/postlayout/AUDIT.md:
*   7 body/plate net(s) tied to the net the schematic puts
*   them on. The extraction deck's connectivity stack does not reach
*   an Nwell, a substrate ring, a bipolar base well or a MiM plate,
*   so they extract isolated and would otherwise float.
*   No ideal device: every golden device is drawn.
*
.subckt bias_core VDD VSS IBIAS VREF BIAS_OK

* --- drawn devices ---
X1 VDD VDD KS1 VSS nfet_03v3 L=8u W=1u nf=1 ad=0.8p as=0.8p pd=3.6u ps=3.6u m=1
X2 KS1 KS1 KS2 VSS nfet_03v3 L=8u W=1u nf=1 ad=0.8p as=0.8p pd=3.6u ps=3.6u m=1
X3 KS2 KS2 KS3 VSS nfet_03v3 L=8u W=1u nf=1 ad=0.8p as=0.8p pd=3.6u ps=3.6u m=1
X4 KS3 KS3 KS4 VSS nfet_03v3 L=8u W=1u nf=1 ad=0.8p as=0.8p pd=3.6u ps=3.6u m=1
X5 KS4 KS4 NKG VSS nfet_03v3 L=8u W=1u nf=1 ad=0.8p as=0.8p pd=3.6u ps=3.6u m=1
X6 PG NKG VSS VSS nfet_03v3 L=4u W=1u nf=1 ad=0.8p as=0.8p pd=3.6u ps=3.6u m=1
X7 NBG NBG VSS VSS nfet_03v3 L=4u W=2u nf=1 ad=1.6p as=1.6p pd=5.6u ps=5.6u m=1
X8 PB NBG VSS VSS nfet_03v3 L=4u W=2u nf=1 ad=1.6p as=1.6p pd=5.6u ps=5.6u m=1
X9 NKM NKM VSS VSS nfet_03v3 L=4u W=2u nf=1 ad=1.6p as=1.6p pd=5.6u ps=5.6u m=1
X10 NOKL NOKL VSS VSS nfet_03v3 L=4u W=2u nf=1 ad=1.6p as=1.6p pd=5.6u ps=5.6u m=1
X11 NOKO NOKL VSS VSS nfet_03v3 L=4u W=2u nf=1 ad=1.6p as=1.6p pd=5.6u ps=5.6u m=1
X12 NOKO NKG VSS VSS nfet_03v3 L=1u W=2u nf=1 ad=1.6p as=1.6p pd=5.6u ps=5.6u m=1
X13 NOKX NOKO VSS VSS nfet_03v3 L=4u W=2u nf=1 ad=1.6p as=1.6p pd=5.6u ps=5.6u m=1
X14 N1 N1 VSS VSS nfet_03v3 L=8u W=4u nf=1 ad=3.2p as=3.2p pd=9.6u ps=9.6u m=1
X15 N2 N1 VSS VSS nfet_03v3 L=8u W=4u nf=1 ad=3.2p as=3.2p pd=9.6u ps=9.6u m=1
X16 BIAS_OK NOKX VSS VSS nfet_03v3 L=0.5u W=4u nf=1 ad=3.2p as=3.2p pd=9.6u ps=9.6u m=1
X17 PG N2 VSS VSS nfet_03v3 L=8u W=8u nf=1 ad=6.4p as=6.4p pd=17.6u ps=17.6u m=1
X18 NKG NKM VSS VSS nfet_03v3 L=4u W=8u nf=1 ad=6.4p as=6.4p pd=17.6u ps=17.6u m=1
X19 NKM PB VDD VDD pfet_03v3 L=4u W=1u nf=1 ad=0.8p as=0.8p pd=3.6u ps=3.6u m=1
X20 TOK PB VDD VDD pfet_03v3 L=4u W=1u nf=1 ad=0.8p as=0.8p pd=3.6u ps=3.6u m=1
X21 NOKX PB VDD VDD pfet_03v3 L=4u W=1u nf=1 ad=0.8p as=0.8p pd=3.6u ps=3.6u m=1
X22 BIAS_OK NOKX VDD VDD pfet_03v3 L=4u W=1u nf=1 ad=0.8p as=0.8p pd=3.6u ps=3.6u m=1
X23 NBG PG VDD VDD pfet_03v3 L=4u W=2u nf=1 ad=1.6p as=1.6p pd=5.6u ps=5.6u m=1
X24 PB PB VDD VDD pfet_03v3 L=4u W=2u nf=1 ad=1.6p as=1.6p pd=5.6u ps=5.6u m=1
X25 NT PB VDD VDD pfet_03v3 L=4u W=2u nf=1 ad=1.6p as=1.6p pd=5.6u ps=5.6u m=1
X26 PG PB VDD VDD pfet_03v3 L=4u W=2u nf=1 ad=1.6p as=1.6p pd=5.6u ps=5.6u m=1
X27 NA PG VDD VDD pfet_03v3 L=4u W=8u nf=1 ad=6.4p as=6.4p pd=17.6u ps=17.6u m=1
X28 NBTOP PG VDD VDD pfet_03v3 L=4u W=8u nf=1 ad=6.4p as=6.4p pd=17.6u ps=17.6u m=1
X29 VREF PG VDD VDD pfet_03v3 L=4u W=8u nf=1 ad=6.4p as=6.4p pd=17.6u ps=17.6u m=1
X30 NOKO NA TOK VDD pfet_03v3 L=4u W=8u nf=1 ad=6.4p as=6.4p pd=17.6u ps=17.6u m=1
X31 NOKL NBTOP TOK VDD pfet_03v3 L=4u W=8u nf=1 ad=6.4p as=6.4p pd=17.6u ps=17.6u m=1
X32 N1 NA NT VDD pfet_03v3 L=4u W=16u nf=1 ad=12.8p as=12.8p pd=33.6u ps=33.6u m=1
X33 N2 NB NT VDD pfet_03v3 L=4u W=16u nf=1 ad=12.8p as=12.8p pd=33.6u ps=33.6u m=1
X34 IBIAS PB VDD VDD pfet_03v3 L=4u W=40u nf=1 ad=32p as=32p pd=81.6u ps=81.6u m=1
X35 VSS VSS EC pnp_10p00x10p00
X36 VSS VSS EC pnp_10p00x10p00
X37 VSS VSS EC pnp_10p00x10p00
X38 VSS VSS EC pnp_10p00x10p00
X39 VSS VSS NA pnp_10p00x10p00
X40 VSS VSS EC pnp_10p00x10p00
X41 VSS VSS ER pnp_10p00x10p00
X42 VSS VSS EC pnp_10p00x10p00
X43 VSS VSS EC pnp_10p00x10p00
X44 VSS VSS EC pnp_10p00x10p00
X45 NOKX VDD cap_mim_2f0_m3m4_noshield c_width=6u c_length=6u
X46 NZ PG cap_mim_2f0_m3m4_noshield c_width=20u c_length=20u
X47 VREF XR2__1 VSS ppolyf_u_3k r_width=2u r_length=256.5u
X48 XR2__2 XR2__1 VSS ppolyf_u_3k r_width=2u r_length=256.5u
X49 XR2__2 XR2__3 VSS ppolyf_u_3k r_width=2u r_length=256.5u
X50 XR2__4 XR2__3 VSS ppolyf_u_3k r_width=2u r_length=256.5u
X51 XR2__4 XR2__5 VSS ppolyf_u_3k r_width=2u r_length=256.5u
X52 XR2__6 XR2__5 VSS ppolyf_u_3k r_width=2u r_length=256.5u
X53 XR2__6 XR2__7 VSS ppolyf_u_3k r_width=2u r_length=256.5u
X54 XR2__8 XR2__7 VSS ppolyf_u_3k r_width=2u r_length=256.5u
X55 XR2__8 XR2__9 VSS ppolyf_u_3k r_width=2u r_length=256.5u
X56 XR2__10 XR2__9 VSS ppolyf_u_3k r_width=2u r_length=256.5u
X57 XR2__10 XR2__11 VSS ppolyf_u_3k r_width=2u r_length=256.5u
X58 XR2__12 XR2__11 VSS ppolyf_u_3k r_width=2u r_length=256.5u
X59 XR2__12 XR2__13 VSS ppolyf_u_3k r_width=2u r_length=256.5u
X60 XR2__14 XR2__13 VSS ppolyf_u_3k r_width=2u r_length=256.5u
X61 XR2__14 XR2__15 VSS ppolyf_u_3k r_width=2u r_length=256.5u
X62 ER XR2__15 VSS ppolyf_u_3k r_width=2u r_length=256.5u
X63 NZ XRZ__1 VSS ppolyf_u_3k r_width=2u r_length=254u
X64 XRZ__2 XRZ__1 VSS ppolyf_u_3k r_width=2u r_length=254u
X65 XRZ__2 XRZ__3 VSS ppolyf_u_3k r_width=2u r_length=254u
X66 N2 XRZ__3 VSS ppolyf_u_3k r_width=2u r_length=254u
X67 NB XR1__1 VSS ppolyf_u_3k r_width=2u r_length=175u
X68 EC XR1__1 VSS ppolyf_u_3k r_width=2u r_length=175u
X69 NBTOP XRT__1 VSS ppolyf_u_3k r_width=2u r_length=8.75u
X70 NB XRT__1 VSS ppolyf_u_3k r_width=2u r_length=8.75u

R_10 N1 N1__par 4967.8583
C_10 N1__par VSS 5.978126e-14
R_11 N2 N2__par 7855.0506
C_11 N2__par VSS 8.4779094e-14
R_12 NKM NKM__par 4876.8874
C_12 NKM__par VSS 5.7923066e-14
R_13 TOK TOK__par 4690.5254
C_13 TOK__par VSS 5.2350545e-14
R_14 NOKO NOKO__par 4792.4183
C_14 NOKO__par VSS 5.9161863e-14
R_15 NOKL NOKL__par 4883.997
C_15 NOKL__par VSS 6.0794305e-14
R_16 NOKX NOKX__par 4848.4085
C_16 NOKX__par VSS 5.9751918e-14
R_17 KS1 KS1__par 4818.8511
C_17 KS1__par VSS 5.4330567e-14
R_18 KS2 KS2__par 4819.3911
C_18 KS2__par VSS 5.4548635e-14
R_19 KS3 KS3__par 4819.931
C_19 KS3__par VSS 5.4766704e-14
R_20 KS4 KS4__par 4820.471
C_20 KS4__par VSS 5.4984773e-14
R_21 NKG NKG__par 4848.0503
C_21 NKG__par VSS 5.7785044e-14
R_23 NB NB__par 7667.0394
C_23 NB__par VSS 7.6118691e-14
R_24 EC EC__par 2791.7858
C_24 EC__par VSS 7.4268842e-14
R_25 NZ NZ__par 2787.2554
C_25 NZ__par VSS 2.545538e-14
R_27 XRZ__2 XRZ__2__par 18.25
C_27 XRZ__2__par VSS 1.8067e-15
R_28 XR2__14 XR2__14__par 18.25
C_28 XR2__14__par VSS 1.8067e-15
R_29 XR2__12 XR2__12__par 18.25
C_29 XR2__12__par VSS 1.8067e-15
R_3 PG PG__par 5084.0134
C_3 PG__par VSS 6.8147207e-14
R_30 XR2__10 XR2__10__par 18.25
C_30 XR2__10__par VSS 1.8067e-15
R_31 XR2__8 XR2__8__par 18.25
C_31 XR2__8__par VSS 1.8067e-15
R_32 XR2__6 XR2__6__par 18.25
C_32 XR2__6__par VSS 1.8067e-15
R_33 XR2__4 XR2__4__par 18.25
C_33 XR2__4__par VSS 1.8067e-15
R_34 XR2__2 XR2__2__par 18.25
C_34 XR2__2__par VSS 1.8067e-15
R_35 NA NA__par 8008.5898
C_35 NA__par VSS 8.7590412e-14
R_36 ER ER__par 2787.674
C_36 ER__par VSS 3.3170077e-14
R_37 XRT__1 XRT__1__par 18.25
C_37 XRT__1__par VSS 1.8067e-15
R_4 NBTOP NBTOP__par 7796.7657
C_4 NBTOP__par VSS 7.8325844e-14
R_43 XR1__1 XR1__1__par 18.25
C_43 XR1__1__par VSS 1.8067e-15
R_44 XRZ__3 XRZ__3__par 18.25
C_44 XRZ__3__par VSS 1.8067e-15
R_45 XRZ__1 XRZ__1__par 18.25
C_45 XRZ__1__par VSS 1.8067e-15
R_46 XR2__13 XR2__13__par 18.25
C_46 XR2__13__par VSS 1.8067e-15
R_47 XR2__11 XR2__11__par 18.25
C_47 XR2__11__par VSS 1.8067e-15
R_48 XR2__1 XR2__1__par 18.25
C_48 XR2__1__par VSS 1.8067e-15
R_49 XR2__3 XR2__3__par 18.25
C_49 XR2__3__par VSS 1.8067e-15
R_50 XR2__5 XR2__5__par 18.25
C_50 XR2__5__par VSS 1.8067e-15
R_51 XR2__7 XR2__7__par 18.25
C_51 XR2__7__par VSS 1.8067e-15
R_52 XR2__9 XR2__9__par 18.25
C_52 XR2__9__par VSS 1.8067e-15
R_53 XR2__15 XR2__15__par 18.25
C_53 XR2__15__par VSS 1.8067e-15
R_6 NBG NBG__par 4871.7578
C_6 NBG__par VSS 5.5851412e-14
R_7 PB PB__par 5396.0003
C_7 PB__par VSS 7.9168117e-14
R_9 NT NT__par 4684.5858
C_9 NT__par VSS 4.9951788e-14
RBIAS_OK BIAS_OK BIAS_OK__par 4679.0384
CBIAS_OK BIAS_OK__par VSS 4.7753184e-14
RIBIAS IBIAS IBIAS__par 4663.4113
CIBIAS IBIAS__par VSS 4.1483963e-14
RVDD VDD VDD__par 371.4414
CVDD VDD__par VSS 1.29011679e-13
RVREF VREF VREF__par 7695.5815
CVREF VREF__par VSS 7.3513489e-14
RVSS VSS VSS__par 145.0301
CVSS VSS__par VSS 2.53093198e-13
.ends bias_core

.control
set numdgt=10
set noaskquit
  tran 20.0u 120.0m
  meas tran vref_st find v(vrefst) at=119.9m
  meas tran vref_end find v(vrefb) at=119.9m
  meas tran t_recover when v(eb)=0.012 fall=last
  meas tran t_ok_last when v(bias_okb)=1.4 rise=last
  meas tran t_false integ v(fob) from=0 to=120.0m
  let m_vref_st = vref_st
  let m_vref_end = vref_end
  let m_t_recover = t_recover
  let m_t_ok_last = t_ok_last
  let m_t_false = t_false
  print m_vref_st
  print m_vref_end
  print m_t_recover
  print m_t_ok_last
  print m_t_false
.endc
.end
