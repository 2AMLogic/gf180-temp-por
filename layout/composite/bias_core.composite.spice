* bias_core -- COMPOSITE post-layout netlist
* generated by layout/composite_netlist.py -- do not edit.
*
* WHAT THIS IS
*   MOS devices and interconnect parasitics taken from the LAYOUT
*     layout/reports/bias_core/extracted-parasitics.spice
*     (klt extract --deck gf180mcu --parasitics), plus every non-MOS
*     device taken VERBATIM from the golden schematic export
*     design/netlist/bias_core.spice.
*
* WHAT THIS IS NOT
*   It is NOT a parasitic-extracted analog core. The vertical PNPs,
*   poly resistors and MiM caps below are IDEAL SCHEMATIC DEVICES:
*   they are not drawn in the layout at all, so they carry no
*   extracted geometry, no parasitic R/C, and no layout-derived
*   matching. Any claim recorded against this netlist must say so in
*   the record's Claim field -- what it substantiates is real
*   interconnect parasitics loading the real MOS topology, and
*   nothing more. See layout/composite/AUDIT.md.
*
*   Device bodies are the other place this netlist takes connectivity
*   from the schematic: the curated deck draws no tap or well-label
*   layer, so an extracted body lands on a global substrate net or an
*   anonymous well net. Those are restored to the schematic's own
*   body nodes here, because a floating body cannot be simulated.
*
.subckt bias_core VDD VSS IBIAS VREF BIAS_OK

* ---- MOS devices: extracted from the layout ----
* device instance $1 r0 *1 159.4,0.5 nfet
XM__1 VDD VDD KS1 VSS nfet_03v3 L=8u W=1u nf=1 ad=0.8p as=0.8p pd=3.6u ps=3.6u m=1
* device instance $2 r0 *1 170,0.5 nfet
XM__2 KS1 KS1 KS2 VSS nfet_03v3 L=8u W=1u nf=1 ad=0.8p as=0.8p pd=3.6u ps=3.6u m=1
* device instance $3 r0 *1 180.6,0.5 nfet
XM__3 KS2 KS2 KS3 VSS nfet_03v3 L=8u W=1u nf=1 ad=0.8p as=0.8p pd=3.6u ps=3.6u m=1
* device instance $4 r0 *1 191.2,0.5 nfet
XM__4 KS3 KS3 KS4 VSS nfet_03v3 L=8u W=1u nf=1 ad=0.8p as=0.8p pd=3.6u ps=3.6u m=1
* device instance $5 r0 *1 201.8,0.5 nfet
XM__5 KS4 KS4 NKG VSS nfet_03v3 L=8u W=1u nf=1 ad=0.8p as=0.8p pd=3.6u ps=3.6u m=1
* device instance $6 r0 *1 223.6,0.5 nfet
XM__6 PG NKG VSS VSS nfet_03v3 L=4u W=1u nf=1 ad=0.8p as=0.8p pd=3.6u ps=3.6u m=1
* device instance $7 r0 *1 112.4,1 nfet
XM__7 NBG NBG VSS VSS nfet_03v3 L=4u W=2u nf=1 ad=1.6p as=1.6p pd=5.6u ps=5.6u m=1
* device instance $8 r0 *1 119,1 nfet
XM__8 PB NBG VSS VSS nfet_03v3 L=4u W=2u nf=1 ad=1.6p as=1.6p pd=5.6u ps=5.6u m=1
* device instance $9 r0 *1 210.4,1 nfet
XM__9 NKM NKM VSS VSS nfet_03v3 L=4u W=2u nf=1 ad=1.6p as=1.6p pd=5.6u ps=5.6u m=1
* device instance $10 r0 *1 230.2,1 nfet
XM__10 NOKL NOKL VSS VSS nfet_03v3 L=4u W=2u nf=1 ad=1.6p as=1.6p pd=5.6u ps=5.6u m=1
* device instance $11 r0 *1 236.8,1 nfet
XM__11 NOKO NOKL VSS VSS nfet_03v3 L=4u W=2u nf=1 ad=1.6p as=1.6p pd=5.6u ps=5.6u m=1
* device instance $12 r0 *1 241.9,1 nfet
XM__12 NOKO NKG VSS VSS nfet_03v3 L=1u W=2u nf=1 ad=1.6p as=1.6p pd=5.6u ps=5.6u m=1
* device instance $13 r0 *1 247,1 nfet
XM__13 NOKX NOKO VSS VSS nfet_03v3 L=4u W=2u nf=1 ad=1.6p as=1.6p pd=5.6u ps=5.6u m=1
* device instance $14 r0 *1 127.6,2 nfet
XM__14 N1 N1 VSS VSS nfet_03v3 L=8u W=4u nf=1 ad=3.2p as=3.2p pd=9.6u ps=9.6u m=1
* device instance $15 r0 *1 138.2,2 nfet
XM__15 N2 N1 VSS VSS nfet_03v3 L=8u W=4u nf=1 ad=3.2p as=3.2p pd=9.6u ps=9.6u m=1
* device instance $16 r0 *1 251.85,2 nfet
XM__16 BIAS_OK NOKX VSS VSS nfet_03v3 L=0.5u W=4u nf=1 ad=3.2p as=3.2p pd=9.6u ps=9.6u m=1
* device instance $17 r0 *1 148.8,4 nfet
XM__17 PG N2 VSS VSS nfet_03v3 L=8u W=8u nf=1 ad=6.4p as=6.4p pd=17.6u ps=17.6u m=1
* device instance $18 r0 *1 217,4 nfet
XM__18 NKG NKM VSS VSS nfet_03v3 L=4u W=8u nf=1 ad=6.4p as=6.4p pd=17.6u ps=17.6u m=1
* device instance $19 r0 *1 68.8,0.5 pfet
XM__19 NKM PB VDD VDD pfet_03v3 L=4u W=1u nf=1 ad=0.8p as=0.8p pd=3.6u ps=3.6u m=1
* device instance $20 r0 *1 75.4,0.5 pfet
XM__20 TOK PB VDD VDD pfet_03v3 L=4u W=1u nf=1 ad=0.8p as=0.8p pd=3.6u ps=3.6u m=1
* device instance $21 r0 *1 95.2,0.5 pfet
XM__21 NOKX PB VDD VDD pfet_03v3 L=4u W=1u nf=1 ad=0.8p as=0.8p pd=3.6u ps=3.6u m=1
* device instance $22 r0 *1 101.8,0.5 pfet
XM__22 BIAS_OK NOKX VDD VDD pfet_03v3 L=4u W=1u nf=1 ad=0.8p as=0.8p pd=3.6u ps=3.6u m=1
* device instance $23 r0 *1 22.6,1 pfet
XM__23 NBG PG VDD VDD pfet_03v3 L=4u W=2u nf=1 ad=1.6p as=1.6p pd=5.6u ps=5.6u m=1
* device instance $24 r0 *1 29.2,1 pfet
XM__24 PB PB VDD VDD pfet_03v3 L=4u W=2u nf=1 ad=1.6p as=1.6p pd=5.6u ps=5.6u m=1
* device instance $25 r0 *1 42.4,1 pfet
XM__25 NT PB VDD VDD pfet_03v3 L=4u W=2u nf=1 ad=1.6p as=1.6p pd=5.6u ps=5.6u m=1
* device instance $26 r0 *1 62.2,1 pfet
XM__26 PG PB VDD VDD pfet_03v3 L=4u W=2u nf=1 ad=1.6p as=1.6p pd=5.6u ps=5.6u m=1
* device instance $27 r0 *1 2.8,4 pfet
XM__27 NA PG VDD VDD pfet_03v3 L=4u W=8u nf=1 ad=6.4p as=6.4p pd=17.6u ps=17.6u m=1
* device instance $28 r0 *1 9.4,4 pfet
XM__28 NBTOP PG VDD VDD pfet_03v3 L=4u W=8u nf=1 ad=6.4p as=6.4p pd=17.6u ps=17.6u m=1
* device instance $29 r0 *1 16,4 pfet
XM__29 VREF PG VDD VDD pfet_03v3 L=4u W=8u nf=1 ad=6.4p as=6.4p pd=17.6u ps=17.6u m=1
* device instance $30 r0 *1 82,4 pfet
XM__30 NOKO NA TOK VDD pfet_03v3 L=4u W=8u nf=1 ad=6.4p as=6.4p pd=17.6u ps=17.6u m=1
* device instance $31 r0 *1 88.6,4 pfet
XM__31 NOKL NBTOP TOK VDD pfet_03v3 L=4u W=8u nf=1 ad=6.4p as=6.4p pd=17.6u ps=17.6u m=1
* device instance $32 r0 *1 49,8 pfet
XM__32 N1 NA NT VDD pfet_03v3 L=4u W=16u nf=1 ad=12.8p as=12.8p pd=33.6u ps=33.6u m=1
* device instance $33 r0 *1 55.6,8 pfet
XM__33 N2 NB NT VDD pfet_03v3 L=4u W=16u nf=1 ad=12.8p as=12.8p pd=33.6u ps=33.6u m=1
* device instance $34 r0 *1 35.8,20 pfet
XM__34 IBIAS PB VDD VDD pfet_03v3 L=4u W=40u nf=1 ad=32p as=32p pd=81.6u ps=81.6u m=1

* ---- interconnect parasitics: extracted from the layout ----
* One series R + one lumped C to substrate per net, from the deck's
* curated sheet-resistance / capacitance table (klt extract
* --parasitics). First order, not a field solve.
Rpar__11 NT NT__par 4684.59
Cpar__11 NT__par VSS 4.99518e-14
Rpar__12 N1 N1__par 4967.86
Cpar__12 N1__par VSS 5.97813e-14
Rpar__13 N2 N2__par 4814.58
Cpar__13 N2__par VSS 5.26042e-14
Rpar__14 NKM NKM__par 4876.89
Cpar__14 NKM__par VSS 5.79231e-14
Rpar__15 TOK TOK__par 4690.53
Cpar__15 TOK__par VSS 5.23505e-14
Rpar__16 NOKO NOKO__par 4792.42
Cpar__16 NOKO__par VSS 5.91619e-14
Rpar__17 NOKL NOKL__par 4884
Cpar__17 NOKL__par VSS 6.07943e-14
Rpar__18 NOKX NOKX__par 4848.41
Cpar__18 NOKX__par VSS 5.97519e-14
Rpar__19 KS1 KS1__par 4818.85
Cpar__19 KS1__par VSS 5.43306e-14
Rpar__20 KS2 KS2__par 4819.39
Cpar__20 KS2__par VSS 5.45486e-14
Rpar__21 KS3 KS3__par 4819.93
Cpar__21 KS3__par VSS 5.47667e-14
Rpar__22 KS4 KS4__par 4820.47
Cpar__22 KS4__par VSS 5.49848e-14
Rpar__23 NKG NKG__par 4848.05
Cpar__23 NKG__par VSS 5.7785e-14
Rpar__3 PG PG__par 5084.01
Cpar__3 PG__par VSS 6.81472e-14
Rpar__4 PB PB__par 5396
Cpar__4 PB__par VSS 7.91681e-14
Rpar__5 NB NB__par 4747.43
Cpar__5 NB__par VSS 4.11174e-14
Rpar__6 NA NA__par 4857.57
Cpar__6 NA__par VSS 5.01637e-14
Rpar__7 NBTOP NBTOP__par 4760.17
Cpar__7 NBTOP__par VSS 4.62236e-14
Rpar__9 NBG NBG__par 4871.76
Cpar__9 NBG__par VSS 5.58514e-14
Rpar_BIAS_OK BIAS_OK BIAS_OK__par 4679.04
Cpar_BIAS_OK BIAS_OK__par VSS 4.77532e-14
Rpar_IBIAS IBIAS IBIAS__par 4663.41
Cpar_IBIAS IBIAS__par VSS 4.1484e-14
Rpar_VDD VDD VDD__par 371.441
Cpar_VDD VDD__par VSS 1.29012e-13
Rpar_VREF VREF VREF__par 4663.23
Cpar_VREF VREF__par VSS 4.14113e-14
Rpar_VSS VSS VSS__par 95.8339
Cpar_VSS VSS__par VSS 1.69497e-13

* ---- non-MOS devices: IDEAL, verbatim from the schematic ----
* Nodes introduced by these devices alone (they exist in no
* extraction, so they carry no parasitics): EC, ER, NZ
* from bias_core
XQ1 VSS VSS NA pnp_10p00x10p00 m=1
* from bias_core
XRT NBTOP NB VSS ppolyf_u_3k r_width=2u r_length=17.5u m=1
* from bias_core
XR1 NB EC VSS ppolyf_u_3k r_width=2u r_length=350.0u m=1
* from bias_core
XQ8A VSS VSS EC pnp_10p00x10p00 m=1
* from bias_core
XQ8B VSS VSS EC pnp_10p00x10p00 m=1
* from bias_core
XQ8C VSS VSS EC pnp_10p00x10p00 m=1
* from bias_core
XQ8D VSS VSS EC pnp_10p00x10p00 m=1
* from bias_core
XQ8E VSS VSS EC pnp_10p00x10p00 m=1
* from bias_core
XQ8F VSS VSS EC pnp_10p00x10p00 m=1
* from bias_core
XQ8G VSS VSS EC pnp_10p00x10p00 m=1
* from bias_core
XQ8H VSS VSS EC pnp_10p00x10p00 m=1
* from bias_core
XR2 VREF ER VSS ppolyf_u_3k r_width=2u r_length=4104.0u m=1
* from bias_core
XQR VSS VSS ER pnp_10p00x10p00 m=1
* from bias_core
XCC PG NZ cap_mim_2f0_m3m4_noshield c_width=20u c_length=20u m=1
* from bias_core
XRZ NZ N2 VSS ppolyf_u_3k r_width=2u r_length=1016.0u m=1
* from bias_core
XCOK VDD NOKX cap_mim_2f0_m3m4_noshield c_width=6u c_length=6u m=1

.ends bias_core
