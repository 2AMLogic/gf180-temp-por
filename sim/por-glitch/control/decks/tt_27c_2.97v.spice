* por-glitch internal-node probe @ tt / 27 C / 2.97 V -- GENERATED by run_glitch_probe.py, do not edit
* pdk=gf180mcuD@c6d73a35f524070e85faff4a6a9eef49553ebc2b

.param vdd_val=2.97
.param stop_s=0.045

.include "/Users/rwalters/.volare/gf180mcuD/libs.tech/ngspice/design.ngspice"
.lib "/Users/rwalters/.volare/gf180mcuD/libs.tech/ngspice/sm141064.ngspice" typical
.lib "/Users/rwalters/.volare/gf180mcuD/libs.tech/ngspice/sm141064.ngspice" res_typical
.lib "/Users/rwalters/.volare/gf180mcuD/libs.tech/ngspice/sm141064.ngspice" bjt_typical
.lib "/Users/rwalters/.volare/gf180mcuD/libs.tech/ngspice/sm141064.ngspice" diode_typical
.lib "/Users/rwalters/.volare/gf180mcuD/libs.tech/ngspice/sm141064.ngspice" moscap_typical
.lib "/Users/rwalters/.volare/gf180mcuD/libs.tech/ngspice/sm141064.ngspice" mimcap_typical

.temp 27.0
.options reltol=1e-5
.options abstol=1e-15
.options vntol=1e-9

.include "../glitch_probe.spice"
.include "../../../../design/netlist/temp_por_top.spice"

.tran 20u {stop_s}

.control
set numdgt=10
set noaskquit
run
wrdata trace.csv v(vdd) v(xdut.por_raw) v(xdut.xpor.pgdg) v(xdut.xpor.pgdgb) v(xdut.vref) v(xdut.bias_ok) v(resetn) v(xdut.xpor.tim) v(xdut.xpor.trip)
.endc
.end
