* extracted by klt extract --deck gf180mcu

* cell por_comparator
* pin BIAS_OK
* pin BIAS_OKB
* pin IBIAS
* pin POR_RAW
* pin VDD
* pin VREF
* pin VSS
.SUBCKT por_comparator BIAS_OK BIAS_OKB IBIAS POR_RAW VDD VREF VSS
* device instance $1 r0 *1 33.5,0.5 nfet
M$1 \$9 \$12 VSS VSS nfet L=10U W=1U AS=0.8P AD=0.8P PS=3.6U PD=3.6U
* device instance $2 r0 *1 52.4,0.5 nfet
M$2 IBIAS BIAS_OKB VSS VSS nfet L=1U W=1U AS=0.8P AD=0.8P PS=3.6U PD=3.6U
* device instance $3 r0 *1 62.45,0.5 nfet
M$3 \$7 \$5 VSS VSS nfet L=0.5U W=1U AS=0.8P AD=0.8P PS=3.6U PD=3.6U
* device instance $4 r0 *1 65.55,0.5 nfet
M$4 POR_RAW \$7 VSS VSS nfet L=0.5U W=1U AS=0.8P AD=0.8P PS=3.6U PD=3.6U
* device instance $5 r0 *1 73.35,0.5 nfet
M$5 BIAS_OKB BIAS_OK VSS VSS nfet L=0.5U W=1U AS=0.5P AD=0.8P PS=3U PD=3.6U
* device instance $6 r0 *1 21.8,1 nfet
M$6 \$4 \$10 \$9 VSS nfet L=1U W=2U AS=1.6P AD=1.6P PS=5.6U PD=5.6U
* device instance $7 r0 *1 25.4,1 nfet
M$7 \$5 VREF \$9 VSS nfet L=1U W=2U AS=1.6P AD=1.6P PS=5.6U PD=5.6U
* device instance $8 r0 *1 42.1,1 nfet
M$8 IBIAS \$12 VSS VSS nfet L=2U W=2U AS=1.6P AD=1.6P PS=5.6U PD=5.6U
* device instance $9 r0 *1 45.95,1 nfet
M$9 IBIAS BIAS_OK \$12 VSS nfet L=0.5U W=2U AS=1.6P AD=1.6P PS=5.6U PD=5.6U
* device instance $10 r0 *1 49.05,1 nfet
M$10 \$12 BIAS_OKB VSS VSS nfet L=0.5U W=2U AS=1.6P AD=1.6P PS=5.6U PD=5.6U
* device instance $11 r0 *1 59.1,1 nfet
M$11 \$5 BIAS_OKB VSS VSS nfet L=1U W=2U AS=1.6P AD=1.6P PS=5.6U PD=5.6U
* device instance $12 r0 *1 55.75,5 nfet
M$12 \$14 \$7 VSS VSS nfet L=0.5U W=10U AS=8P AD=8P PS=21.6U PD=21.6U
* device instance $13 r0 *1 11.35,1 pfet
M$13 \$7 \$5 VDD VDD pfet L=0.5U W=2U AS=1.6P AD=1.6P PS=5.6U PD=5.6U
* device instance $14 r0 *1 14.45,1 pfet
M$14 POR_RAW \$7 VDD VDD pfet L=0.5U W=2U AS=1.6P AD=1.6P PS=5.6U PD=5.6U
* device instance $15 r0 *1 1.3,2 pfet
M$15 \$4 \$4 \$3 VDD pfet L=1U W=4U AS=3.2P AD=3.2P PS=9.6U PD=9.6U
* device instance $16 r0 *1 4.9,2 pfet
M$16 \$5 \$4 \$3 VDD pfet L=1U W=4U AS=3.2P AD=3.2P PS=9.6U PD=9.6U
* device instance $17 r0 *1 8.25,2 pfet
M$17 \$3 BIAS_OKB VDD VDD pfet L=0.5U W=4U AS=3.2P AD=3.2P PS=9.6U PD=9.6U
* device instance $18 r0 *1 73.35,4 pfet
M$18 BIAS_OKB BIAS_OK VDD \$16 pfet L=0.5U W=2U AS=1P AD=1.6P PS=5U PD=5.6U
* device instance $19 r0 *1 309,68.04 ppolyf_u_1k
R$19 \$14 \$10 VSS 3384615 ppolyf_u_1k L=6769.23U W=2U
* device instance $20 r0 *1 410,18.87 ppolyf_u_1k
R$20 VSS \$14 VSS 387500 ppolyf_u_1k L=775U W=2U
* device instance $21 r0 *1 157,73.45 ppolyf_u_1k
R$21 \$10 VDD VSS 3948720 ppolyf_u_1k L=7897.44U W=2U
.ENDS por_comparator
