* temp_por_top -- post-layout netlist
* GENERATED by layout/postlayout.py -- do not edit.
*
* FROM THE LAYOUT: every device and its dimensions, the whole
*   topology, and first-order interconnect R/C on 136/145 nets
*   (sigma 5900.5 fF). klt 0.2.0, deck gf180mcu,
*   GDS sha256 33843b0e8f9f28a9...
* Net names are the schematic's, restored through klt lvs's own net
*   correspondence -- match, 145/145 nets, every one paired.
*
* NOT FROM THE LAYOUT -- see layout/postlayout/AUDIT.md:
*   9 body/plate net(s) tied to the net the schematic puts
*   them on. The extraction deck's connectivity stack does not reach
*   an Nwell, a substrate ring, a bipolar base well or a MiM plate,
*   so they extract isolated and would otherwise float.
*   XCC (cap_mim_2f0_m3m4_noshield) is IDEAL -- not drawn in this cell's layout -- reserved floor area.
*
.subckt temp_por_top VDD VSS PTAT CTAT RESETn

* --- schematic-ideal, not drawn ---
XIDEAL1 xtemp__PG xtemp__NZ cap_mim_2f0_m3m4_noshield c_width=12u c_length=12u

* --- drawn devices ---
X1 xbias__NBG xbias__NBG VSS VSS nfet_03v3 L=4u W=2u nf=1 ad=1.6p as=1.6p pd=5.6u ps=5.6u m=1
X2 xbias__PB xbias__NBG VSS VSS nfet_03v3 L=4u W=2u nf=1 ad=1.6p as=1.6p pd=5.6u ps=5.6u m=1
X3 xbias__N1 xbias__N1 VSS VSS nfet_03v3 L=8u W=4u nf=1 ad=3.2p as=3.2p pd=9.6u ps=9.6u m=1
X4 xbias__N2 xbias__N1 VSS VSS nfet_03v3 L=8u W=4u nf=1 ad=3.2p as=3.2p pd=9.6u ps=9.6u m=1
X5 xbias__PG xbias__N2 VSS VSS nfet_03v3 L=8u W=8u nf=1 ad=6.4p as=6.4p pd=17.6u ps=17.6u m=1
X6 VDD VDD xbias__KS1 VSS nfet_03v3 L=8u W=1u nf=1 ad=0.8p as=0.8p pd=3.6u ps=3.6u m=1
X7 xbias__KS1 xbias__KS1 xbias__KS2 VSS nfet_03v3 L=8u W=1u nf=1 ad=0.8p as=0.8p pd=3.6u ps=3.6u m=1
X8 xbias__KS2 xbias__KS2 xbias__KS3 VSS nfet_03v3 L=8u W=1u nf=1 ad=0.8p as=0.8p pd=3.6u ps=3.6u m=1
X9 xbias__KS3 xbias__KS3 xbias__KS4 VSS nfet_03v3 L=8u W=1u nf=1 ad=0.8p as=0.8p pd=3.6u ps=3.6u m=1
X10 xbias__KS4 xbias__KS4 xbias__NKG VSS nfet_03v3 L=8u W=1u nf=1 ad=0.8p as=0.8p pd=3.6u ps=3.6u m=1
X11 xbias__NKM xbias__NKM VSS VSS nfet_03v3 L=4u W=2u nf=1 ad=1.6p as=1.6p pd=5.6u ps=5.6u m=1
X12 xbias__NKG xbias__NKM VSS VSS nfet_03v3 L=4u W=8u nf=1 ad=6.4p as=6.4p pd=17.6u ps=17.6u m=1
X13 xbias__PG xbias__NKG VSS VSS nfet_03v3 L=4u W=1u nf=1 ad=0.8p as=0.8p pd=3.6u ps=3.6u m=1
X14 xbias__NOKL xbias__NOKL VSS VSS nfet_03v3 L=4u W=2u nf=1 ad=1.6p as=1.6p pd=5.6u ps=5.6u m=1
X15 xbias__NOKO xbias__NOKL VSS VSS nfet_03v3 L=4u W=2u nf=1 ad=1.6p as=1.6p pd=5.6u ps=5.6u m=1
X16 xbias__NOKO xbias__NKG VSS VSS nfet_03v3 L=1u W=2u nf=1 ad=1.6p as=1.6p pd=5.6u ps=5.6u m=1
X17 xbias__NOKX xbias__NOKO VSS VSS nfet_03v3 L=4u W=2u nf=1 ad=1.6p as=1.6p pd=5.6u ps=5.6u m=1
X18 BIAS_OK xbias__NOKX VSS VSS nfet_03v3 L=0.5u W=4u nf=1 ad=3.2p as=3.2p pd=9.6u ps=9.6u m=1
X19 xcmp__NA xcmp__SNS xcmp__TN VSS nfet_03v3 L=1u W=2u nf=1 ad=1.6p as=1.6p pd=5.6u ps=5.6u m=1
X20 xcmp__CMPO VREF xcmp__TN VSS nfet_03v3 L=1u W=2u nf=1 ad=1.6p as=1.6p pd=5.6u ps=5.6u m=1
X21 xcmp__TN xcmp__NBG VSS VSS nfet_03v3 L=10u W=1u nf=1 ad=0.8p as=0.8p pd=3.6u ps=3.6u m=1
X22 IBIAS xcmp__NBG VSS VSS nfet_03v3 L=2u W=2u nf=1 ad=1.6p as=1.6p pd=5.6u ps=5.6u m=1
X23 IBIAS BIAS_OK xcmp__NBG VSS nfet_03v3 L=0.5u W=2u nf=1 ad=1.6p as=1.6p pd=5.6u ps=5.6u m=1
X24 xcmp__NBG xcmp__BIAS_OKB VSS VSS nfet_03v3 L=0.5u W=2u nf=1 ad=1.6p as=1.6p pd=5.6u ps=5.6u m=1
X25 IBIAS xcmp__BIAS_OKB VSS VSS nfet_03v3 L=1u W=1u nf=1 ad=0.8p as=0.8p pd=3.6u ps=3.6u m=1
X26 xcmp__SNSB xcmp__N1 VSS VSS nfet_03v3 L=0.5u W=10u nf=1 ad=8p as=8p pd=21.6u ps=21.6u m=1
X27 xcmp__CMPO xcmp__BIAS_OKB VSS VSS nfet_03v3 L=1u W=2u nf=1 ad=1.6p as=1.6p pd=5.6u ps=5.6u m=1
X28 xcmp__N1 xcmp__CMPO VSS VSS nfet_03v3 L=0.5u W=1u nf=1 ad=0.8p as=0.8p pd=3.6u ps=3.6u m=1
X29 POR_RAW xcmp__N1 VSS VSS nfet_03v3 L=0.5u W=1u nf=1 ad=0.8p as=0.8p pd=3.6u ps=3.6u m=1
X30 xcmp__BIAS_OKB BIAS_OK VSS VSS nfet_03v3 L=0.5u W=1u nf=1 ad=0.8p as=0.5p pd=3.6u ps=3u m=1
X31 IBIAS IBIAS VSS VSS nfet_03v3 L=4u W=4u nf=1 ad=3.2p as=3.2p pd=9.6u ps=9.6u m=1
X32 xpor__PDN IBIAS VSS VSS nfet_03v3 L=25u W=0.5u nf=1 ad=0.4p as=0.4p pd=2.6u ps=2.6u m=1
X33 xpor__NDL xpor__NDL VSS VSS nfet_03v3 L=10u W=2u nf=1 ad=1.6p as=1.6p pd=5.6u ps=5.6u m=1
X34 xpor__NDGN xpor__NDL VSS VSS nfet_03v3 L=10u W=10u nf=1 ad=8p as=8p pd=21.6u ps=21.6u m=1
X35 xpor__NDG POR_RAW xpor__NDGN VSS nfet_03v3 L=0.5u W=1u nf=1 ad=0.8p as=0.8p pd=3.6u ps=3.6u m=1
X36 xpor__PGDG xpor__NDG VSS VSS nfet_03v3 L=0.5u W=2u nf=1 ad=1.6p as=1.6p pd=5.6u ps=5.6u m=1
X37 xpor__PGDGB xpor__PGDG VSS VSS nfet_03v3 L=2u W=0.5u nf=1 ad=0.4p as=0.4p pd=2.6u ps=2.6u m=1
X38 xpor__TIM xpor__PGDGB VSS VSS nfet_03v3 L=1u W=1u nf=1 ad=0.8p as=0.8p pd=3.6u ps=3.6u m=1
X39 xpor__ND1 xpor__NDL VSS VSS nfet_03v3 L=10u W=0.5u nf=1 ad=0.4p as=0.4p pd=2.6u ps=2.6u m=1
X40 xpor__TRIP xpor__ND1 VSS VSS nfet_03v3 L=1u W=1u nf=1 ad=0.8p as=0.8p pd=3.6u ps=3.6u m=1
X41 xpor__ND1 RESETn VSS VSS nfet_03v3 L=1u W=1u nf=1 ad=0.8p as=0.8p pd=3.6u ps=3.6u m=1
X42 xpor__RSTB xpor__TRIP xpor__NNAND VSS nfet_03v3 L=0.5u W=2u nf=1 ad=1.6p as=1.6p pd=5.6u ps=5.6u m=1
X43 xpor__NNAND xpor__PGDG VSS VSS nfet_03v3 L=0.5u W=2u nf=1 ad=1.6p as=1.6p pd=5.6u ps=5.6u m=1
X44 RESETn xpor__RSTB VSS VSS nfet_03v3 L=0.5u W=10u nf=1 ad=8p as=8p pd=21.6u ps=21.6u m=1
X45 VSS VSS VSS VSS nfet_03v3 L=8u W=4u nf=1 ad=3.2p as=3.2p pd=9.6u ps=9.6u m=1
X46 xtemp__N1 xtemp__N1 VSS VSS nfet_03v3 L=8u W=4u nf=1 ad=3.2p as=3.2p pd=9.6u ps=9.6u m=1
X47 xtemp__N2 xtemp__N1 VSS VSS nfet_03v3 L=8u W=4u nf=1 ad=3.2p as=3.2p pd=9.6u ps=9.6u m=1
X48 xtemp__N2 xtemp__N1 VSS VSS nfet_03v3 L=8u W=4u nf=1 ad=3.2p as=3.2p pd=9.6u ps=9.6u m=1
X49 xtemp__N1 xtemp__N1 VSS VSS nfet_03v3 L=8u W=4u nf=1 ad=3.2p as=3.2p pd=9.6u ps=9.6u m=1
X50 VSS VSS VSS VSS nfet_03v3 L=8u W=4u nf=1 ad=3.2p as=3.2p pd=9.6u ps=9.6u m=1
X51 xtemp__PG xtemp__N2 VSS VSS nfet_03v3 L=8u W=8u nf=1 ad=6.4p as=6.4p pd=17.6u ps=17.6u m=1
X52 IBIAS xtemp__NBG VSS VSS nfet_03v3 L=2u W=4u nf=1 ad=3.2p as=3.2p pd=9.6u ps=9.6u m=1
X53 IBIAS RESETn xtemp__NBG VSS nfet_03v3 L=0.5u W=2u nf=1 ad=1.6p as=1.6p pd=5.6u ps=5.6u m=1
X54 xtemp__NBG xtemp__ENB VSS VSS nfet_03v3 L=0.5u W=2u nf=1 ad=1.6p as=1.6p pd=5.6u ps=5.6u m=1
X55 xtemp__PB xtemp__NBG VSS VSS nfet_03v3 L=2u W=4u nf=1 ad=3.2p as=3.2p pd=9.6u ps=9.6u m=1
X56 xtemp__PCAS xtemp__NBG VSS VSS nfet_03v3 L=2u W=4u nf=1 ad=3.2p as=3.2p pd=9.6u ps=9.6u m=1
X57 xtemp__ENB RESETn VSS VSS nfet_03v3 L=0.5u W=1u nf=1 ad=0.8p as=0.8p pd=3.6u ps=3.6u m=1
X58 xtemp__ND xtemp__NR VSS VSS nfet_03v3 L=2u W=2u nf=1 ad=1.6p as=1.6p pd=5.6u ps=5.6u m=1
X59 xtemp__PG xtemp__ND VSS VSS nfet_03v3 L=1u W=4u nf=1 ad=3.2p as=3.2p pd=9.6u ps=9.6u m=1
X60 xtemp__NR xtemp__NR VSS VSS nfet_03v3 L=2u W=2u nf=1 ad=1.6p as=1.6p pd=5.6u ps=5.6u m=1
X61 xtemp__ND xtemp__ENB VSS VSS nfet_03v3 L=0.5u W=2u nf=1 ad=1.6p as=1.6p pd=5.6u ps=5.6u m=1
X62 PTAT xtemp__ENB VSS VSS nfet_03v3 L=1u W=1u nf=1 ad=0.8p as=0.8p pd=3.6u ps=3.6u m=1
X63 CTAT xtemp__ENB VSS VSS nfet_03v3 L=1u W=1u nf=1 ad=0.8p as=0.8p pd=3.6u ps=3.6u m=1
X64 xtemp__N2 xtemp__ENB VSS VSS nfet_03v3 L=1u W=2u nf=1 ad=1.6p as=1.6p pd=5.6u ps=5.6u m=1
X65 xtemp__NT xtemp__ENB VSS VSS nfet_03v3 L=1u W=2u nf=1 ad=1.6p as=1.6p pd=5.6u ps=5.6u m=1
X66 xtemp__T5 VDD xtemp__T4 VSS nfet_03v3 L=0.5u W=32u nf=1 ad=25.6p as=25.6p pd=65.6u ps=65.6u m=1
X67 xtemp__T3 VSS xtemp__T2 VSS nfet_03v3 L=0.5u W=32u nf=1 ad=25.6p as=25.6p pd=65.6u ps=65.6u m=1
X68 xtemp__T1 VSS xtemp__T0 VSS nfet_03v3 L=0.5u W=32u nf=1 ad=25.6p as=25.6p pd=65.6u ps=65.6u m=1
X69 xtemp__T0 VSS VSS VSS nfet_03v3 L=0.5u W=32u nf=1 ad=25.6p as=25.6p pd=65.6u ps=65.6u m=1
X70 xtemp__T2 VSS xtemp__T1 VSS nfet_03v3 L=0.5u W=32u nf=1 ad=25.6p as=25.6p pd=65.6u ps=65.6u m=1
X71 xtemp__T4 VSS xtemp__T3 VSS nfet_03v3 L=0.5u W=32u nf=1 ad=25.6p as=25.6p pd=65.6u ps=65.6u m=1
X72 xbias__NA xbias__PG VDD VDD pfet_03v3 L=4u W=8u nf=1 ad=6.4p as=6.4p pd=17.6u ps=17.6u m=1
X73 xbias__NBTOP xbias__PG VDD VDD pfet_03v3 L=4u W=8u nf=1 ad=6.4p as=6.4p pd=17.6u ps=17.6u m=1
X74 VREF xbias__PG VDD VDD pfet_03v3 L=4u W=8u nf=1 ad=6.4p as=6.4p pd=17.6u ps=17.6u m=1
X75 xbias__NBG xbias__PG VDD VDD pfet_03v3 L=4u W=2u nf=1 ad=1.6p as=1.6p pd=5.6u ps=5.6u m=1
X76 xbias__PB xbias__PB VDD VDD pfet_03v3 L=4u W=2u nf=1 ad=1.6p as=1.6p pd=5.6u ps=5.6u m=1
X77 IBIAS xbias__PB VDD VDD pfet_03v3 L=4u W=40u nf=1 ad=32p as=32p pd=81.6u ps=81.6u m=1
X78 xbias__NT xbias__PB VDD VDD pfet_03v3 L=4u W=2u nf=1 ad=1.6p as=1.6p pd=5.6u ps=5.6u m=1
X79 xbias__N1 xbias__NA xbias__NT VDD pfet_03v3 L=4u W=16u nf=1 ad=12.8p as=12.8p pd=33.6u ps=33.6u m=1
X80 xbias__N2 xbias__NB xbias__NT VDD pfet_03v3 L=4u W=16u nf=1 ad=12.8p as=12.8p pd=33.6u ps=33.6u m=1
X81 xbias__PG xbias__PB VDD VDD pfet_03v3 L=4u W=2u nf=1 ad=1.6p as=1.6p pd=5.6u ps=5.6u m=1
X82 xbias__NKM xbias__PB VDD VDD pfet_03v3 L=4u W=1u nf=1 ad=0.8p as=0.8p pd=3.6u ps=3.6u m=1
X83 xbias__TOK xbias__PB VDD VDD pfet_03v3 L=4u W=1u nf=1 ad=0.8p as=0.8p pd=3.6u ps=3.6u m=1
X84 xbias__NOKO xbias__NA xbias__TOK VDD pfet_03v3 L=4u W=8u nf=1 ad=6.4p as=6.4p pd=17.6u ps=17.6u m=1
X85 xbias__NOKL xbias__NBTOP xbias__TOK VDD pfet_03v3 L=4u W=8u nf=1 ad=6.4p as=6.4p pd=17.6u ps=17.6u m=1
X86 xbias__NOKX xbias__PB VDD VDD pfet_03v3 L=4u W=1u nf=1 ad=0.8p as=0.8p pd=3.6u ps=3.6u m=1
X87 BIAS_OK xbias__NOKX VDD VDD pfet_03v3 L=4u W=1u nf=1 ad=0.8p as=0.8p pd=3.6u ps=3.6u m=1
X88 xcmp__NA xcmp__NA xcmp__VDDA VDD pfet_03v3 L=1u W=4u nf=1 ad=3.2p as=3.2p pd=9.6u ps=9.6u m=1
X89 xcmp__CMPO xcmp__NA xcmp__VDDA VDD pfet_03v3 L=1u W=4u nf=1 ad=3.2p as=3.2p pd=9.6u ps=9.6u m=1
X90 xcmp__VDDA xcmp__BIAS_OKB VDD VDD pfet_03v3 L=0.5u W=4u nf=1 ad=3.2p as=3.2p pd=9.6u ps=9.6u m=1
X91 xcmp__N1 xcmp__CMPO VDD VDD pfet_03v3 L=0.5u W=2u nf=1 ad=1.6p as=1.6p pd=5.6u ps=5.6u m=1
X92 POR_RAW xcmp__N1 VDD VDD pfet_03v3 L=0.5u W=2u nf=1 ad=1.6p as=1.6p pd=5.6u ps=5.6u m=1
X93 xpor__PDN xpor__PDN VDD VDD pfet_03v3 L=10u W=2u nf=1 ad=1.6p as=1.6p pd=5.6u ps=5.6u m=1
X94 xpor__NDL xpor__PDN VDD VDD pfet_03v3 L=10u W=2u nf=1 ad=1.6p as=1.6p pd=5.6u ps=5.6u m=1
X95 xpor__NDGP xpor__PDN VDD VDD pfet_03v3 L=10u W=10u nf=1 ad=8p as=8p pd=21.6u ps=21.6u m=1
X96 xpor__NTS xpor__PDN VDD VDD pfet_03v3 L=10u W=0.5u nf=1 ad=0.4p as=0.4p pd=2.6u ps=2.6u m=1
X97 xpor__TRIP xpor__PDN VDD VDD pfet_03v3 L=10u W=0.5u nf=1 ad=0.4p as=0.4p pd=2.6u ps=2.6u m=1
X98 xpor__NDG POR_RAW xpor__NDGP VDD pfet_03v3 L=0.5u W=1u nf=1 ad=0.8p as=0.8p pd=3.6u ps=3.6u m=1
X99 xpor__PGDG xpor__NDG VDD VDD pfet_03v3 L=2u W=0.5u nf=1 ad=0.4p as=0.4p pd=2.6u ps=2.6u m=1
X100 xpor__PGDGB xpor__PGDG VDD VDD pfet_03v3 L=0.5u W=2u nf=1 ad=1.6p as=1.6p pd=5.6u ps=5.6u m=1
X101 xpor__TIM xpor__PGDGB xpor__NTS VDD pfet_03v3 L=1u W=2u nf=1 ad=1.6p as=1.6p pd=5.6u ps=5.6u m=1
X102 xpor__ND1 xpor__TIM VDD VDD pfet_03v3 L=1u W=2u nf=1 ad=1.6p as=1.6p pd=5.6u ps=5.6u m=1
X103 xpor__RSTB xpor__TRIP VDD VDD pfet_03v3 L=0.5u W=4u nf=1 ad=3.2p as=3.2p pd=9.6u ps=9.6u m=1
X104 xpor__RSTB xpor__PGDG VDD VDD pfet_03v3 L=0.5u W=4u nf=1 ad=3.2p as=3.2p pd=9.6u ps=9.6u m=1
X105 xpor__RSTB RESETn VDD VDD pfet_03v3 L=10u W=0.5u nf=1 ad=0.4p as=0.4p pd=2.6u ps=2.6u m=1
X106 RESETn xpor__RSTB VDD VDD pfet_03v3 L=1u W=1u nf=1 ad=0.8p as=0.8p pd=3.6u ps=3.6u m=1
X107 xtemp__NT xtemp__NT xtemp__NT xtemp__NT pfet_03v3 L=4u W=16u nf=1 ad=12.8p as=12.8p pd=33.6u ps=33.6u m=1
X108 xtemp__N1 xtemp__NA xtemp__NT xtemp__NT pfet_03v3 L=4u W=16u nf=1 ad=12.8p as=12.8p pd=33.6u ps=33.6u m=1
X109 xtemp__N2 xtemp__NB xtemp__NT xtemp__NT pfet_03v3 L=4u W=16u nf=1 ad=12.8p as=12.8p pd=33.6u ps=33.6u m=1
X110 xtemp__N2 xtemp__NB xtemp__NT xtemp__NT pfet_03v3 L=4u W=16u nf=1 ad=12.8p as=12.8p pd=33.6u ps=33.6u m=1
X111 xtemp__N1 xtemp__NA xtemp__NT xtemp__NT pfet_03v3 L=4u W=16u nf=1 ad=12.8p as=12.8p pd=33.6u ps=33.6u m=1
X112 xtemp__NT xtemp__NT xtemp__NT xtemp__NT pfet_03v3 L=4u W=16u nf=1 ad=12.8p as=12.8p pd=33.6u ps=33.6u m=1
X113 xtemp__NT xtemp__PB VDD VDD pfet_03v3 L=4u W=20u nf=1 ad=16p as=16p pd=41.6u ps=41.6u m=1
X114 VDD VDD VDD VDD pfet_03v3 L=4u W=4u nf=1 ad=3.2p as=3.2p pd=9.6u ps=9.6u m=1
X115 xtemp__M1D xtemp__PG VDD VDD pfet_03v3 L=4u W=4u nf=1 ad=3.2p as=3.2p pd=9.6u ps=9.6u m=1
X116 xtemp__NA xtemp__PCAS xtemp__M1D VDD pfet_03v3 L=1u W=4u nf=1 ad=3.2p as=3.2p pd=9.6u ps=9.6u m=1
X117 xtemp__M2D xtemp__PG VDD VDD pfet_03v3 L=4u W=4u nf=1 ad=3.2p as=3.2p pd=9.6u ps=9.6u m=1
X118 xtemp__NB xtemp__PCAS xtemp__M2D VDD pfet_03v3 L=1u W=4u nf=1 ad=3.2p as=3.2p pd=9.6u ps=9.6u m=1
X119 xtemp__M3D xtemp__PG VDD VDD pfet_03v3 L=4u W=4u nf=1 ad=3.2p as=3.2p pd=9.6u ps=9.6u m=1
X120 PTAT xtemp__PCAS xtemp__M3D VDD pfet_03v3 L=1u W=4u nf=1 ad=3.2p as=3.2p pd=9.6u ps=9.6u m=1
X121 PTAT xtemp__PCAS xtemp__M3D VDD pfet_03v3 L=1u W=4u nf=1 ad=3.2p as=3.2p pd=9.6u ps=9.6u m=1
X122 xtemp__M3D xtemp__PG VDD VDD pfet_03v3 L=4u W=4u nf=1 ad=3.2p as=3.2p pd=9.6u ps=9.6u m=1
X123 xtemp__NB xtemp__PCAS xtemp__M2D VDD pfet_03v3 L=1u W=4u nf=1 ad=3.2p as=3.2p pd=9.6u ps=9.6u m=1
X124 xtemp__M2D xtemp__PG VDD VDD pfet_03v3 L=4u W=4u nf=1 ad=3.2p as=3.2p pd=9.6u ps=9.6u m=1
X125 xtemp__NA xtemp__PCAS xtemp__M1D VDD pfet_03v3 L=1u W=4u nf=1 ad=3.2p as=3.2p pd=9.6u ps=9.6u m=1
X126 xtemp__M1D xtemp__PG VDD VDD pfet_03v3 L=4u W=4u nf=1 ad=3.2p as=3.2p pd=9.6u ps=9.6u m=1
X127 VDD VDD VDD VDD pfet_03v3 L=4u W=4u nf=1 ad=3.2p as=3.2p pd=9.6u ps=9.6u m=1
X128 xtemp__PG xtemp__PB VDD VDD pfet_03v3 L=4u W=10u nf=1 ad=8p as=8p pd=21.6u ps=21.6u m=1
X129 xtemp__PB xtemp__PB VDD VDD pfet_03v3 L=4u W=10u nf=1 ad=8p as=8p pd=21.6u ps=21.6u m=1
X130 xtemp__PCAS xtemp__PCAS VDD VDD pfet_03v3 L=8u W=1u nf=1 ad=0.8p as=0.8p pd=3.6u ps=3.6u m=1
X131 xtemp__ENB RESETn VDD VDD pfet_03v3 L=0.5u W=2u nf=1 ad=1.6p as=1.6p pd=5.6u ps=5.6u m=1
X132 xtemp__ND xtemp__PB VDD VDD pfet_03v3 L=8u W=1u nf=1 ad=0.8p as=0.8p pd=3.6u ps=3.6u m=1
X133 xtemp__NR xtemp__PG VDD VDD pfet_03v3 L=4u W=1u nf=1 ad=0.8p as=0.8p pd=3.6u ps=3.6u m=1
X134 xtemp__PG RESETn VDD VDD pfet_03v3 L=0.5u W=4u nf=1 ad=3.2p as=3.2p pd=9.6u ps=9.6u m=1
X135 xcmp__BIAS_OKB BIAS_OK VDD VDD pfet_03v3 L=0.5u W=2u nf=1 ad=1.6p as=1p pd=5.6u ps=5u m=1
X136 VSS VSS xbias__EC pnp_10p00x10p00
X137 VSS VSS xbias__EC pnp_10p00x10p00
X138 VSS VSS xbias__EC pnp_10p00x10p00
X139 VSS VSS xbias__EC pnp_10p00x10p00
X140 VSS VSS xbias__NA pnp_10p00x10p00
X141 VSS VSS xbias__EC pnp_10p00x10p00
X142 VSS VSS xbias__ER pnp_10p00x10p00
X143 VSS VSS xbias__EC pnp_10p00x10p00
X144 VSS VSS xbias__EC pnp_10p00x10p00
X145 VSS VSS xbias__EC pnp_10p00x10p00
X146 VSS VSS xtemp__NC pnp_10p00x10p00
X147 VSS VSS xtemp__NC pnp_10p00x10p00
X148 VSS VSS xtemp__NC pnp_10p00x10p00
X149 VSS VSS xtemp__NC pnp_10p00x10p00
X150 VSS VSS xtemp__NA pnp_10p00x10p00
X151 VSS VSS xtemp__NC pnp_10p00x10p00
X152 VSS VSS xtemp__NC pnp_10p00x10p00
X153 VSS VSS xtemp__NC pnp_10p00x10p00
X154 VSS VSS xtemp__NC pnp_10p00x10p00
X155 xpor__NDG VSS cap_mim_2f0_m3m4_noshield c_width=11u c_length=11u
X156 xpor__TIM VSS cap_mim_2f0_m3m4_noshield c_width=28u c_length=28u
X157 xpor__TIM VSS cap_mim_2f0_m3m4_noshield c_width=28u c_length=28u
X158 VDD xbias__NOKX cap_mim_2f0_m3m4_noshield c_width=6u c_length=6u
X159 xbias__PG xbias__NZ cap_mim_2f0_m3m4_noshield c_width=20u c_length=20u
X160 xpor__TIM VSS cap_mim_2f0_m3m4_noshield c_width=28u c_length=28u
X161 xpor__TIM VSS cap_mim_2f0_m3m4_noshield c_width=28u c_length=28u
X162 xtemp__NB xtemp__XR1__1 VSS ppolyf_u r_width=2u r_length=59.735u
X163 xtemp__NC xtemp__XR1__1 VSS ppolyf_u r_width=2u r_length=59.735u
X164 xtemp__NA xtemp__XRISO__1 VSS ppolyf_u r_width=2u r_length=55.525u
X165 CTAT xtemp__XRISO__1 VSS ppolyf_u r_width=2u r_length=55.525u
X166 xtemp__NZ xtemp__XRZ__1 VSS ppolyf_u r_width=2u r_length=100u
X167 xtemp__XRZ__2 xtemp__XRZ__1 VSS ppolyf_u r_width=2u r_length=100u
X168 xtemp__XRZ__2 xtemp__XRZ__3 VSS ppolyf_u r_width=2u r_length=100u
X169 xtemp__XRZ__4 xtemp__XRZ__3 VSS ppolyf_u r_width=2u r_length=100u
X170 xtemp__XRZ__4 xtemp__XRZ__5 VSS ppolyf_u r_width=2u r_length=100u
X171 xtemp__XRZ__6 xtemp__XRZ__5 VSS ppolyf_u r_width=2u r_length=100u
X172 xtemp__XRZ__6 xtemp__XRZ__7 VSS ppolyf_u r_width=2u r_length=100u
X173 xtemp__XRZ__8 xtemp__XRZ__7 VSS ppolyf_u r_width=2u r_length=100u
X174 xtemp__XRZ__8 xtemp__XRZ__9 VSS ppolyf_u r_width=2u r_length=100u
X175 xtemp__N2 xtemp__XRZ__9 VSS ppolyf_u r_width=2u r_length=100u
X176 PTAT xtemp__XR2F__1 VSS ppolyf_u r_width=2u r_length=110.525u
X177 xtemp__XR2F__2 xtemp__XR2F__1 VSS ppolyf_u r_width=2u r_length=110.525u
X178 xtemp__XR2F__2 xtemp__XR2F__3 VSS ppolyf_u r_width=2u r_length=110.525u
X179 xtemp__XR2F__4 xtemp__XR2F__3 VSS ppolyf_u r_width=2u r_length=110.525u
X180 xtemp__XR2F__4 xtemp__XR2F__5 VSS ppolyf_u r_width=2u r_length=110.525u
X181 xtemp__XR2F__6 xtemp__XR2F__5 VSS ppolyf_u r_width=2u r_length=110.525u
X182 xtemp__XR2F__6 xtemp__XR2F__7 VSS ppolyf_u r_width=2u r_length=110.525u
X183 xtemp__XR2F__8 xtemp__XR2F__7 VSS ppolyf_u r_width=2u r_length=110.525u
X184 xtemp__XR2F__8 xtemp__XR2F__9 VSS ppolyf_u r_width=2u r_length=110.525u
X185 xtemp__XR2F__10 xtemp__XR2F__9 VSS ppolyf_u r_width=2u r_length=110.525u
X186 xtemp__XR2F__10 xtemp__XR2F__11 VSS ppolyf_u r_width=2u r_length=110.525u
X187 xtemp__XR2F__12 xtemp__XR2F__11 VSS ppolyf_u r_width=2u r_length=110.525u
X188 xtemp__XR2F__12 xtemp__XR2F__13 VSS ppolyf_u r_width=2u r_length=110.525u
X189 xtemp__XR2F__14 xtemp__XR2F__13 VSS ppolyf_u r_width=2u r_length=110.525u
X190 xtemp__XR2F__14 xtemp__XR2F__15 VSS ppolyf_u r_width=2u r_length=110.525u
X191 xtemp__XR2F__16 xtemp__XR2F__15 VSS ppolyf_u r_width=2u r_length=110.525u
X192 xtemp__XR2F__16 xtemp__XR2F__17 VSS ppolyf_u r_width=2u r_length=110.525u
X193 xtemp__XR2F__18 xtemp__XR2F__17 VSS ppolyf_u r_width=2u r_length=110.525u
X194 xtemp__XR2F__18 xtemp__XR2F__19 VSS ppolyf_u r_width=2u r_length=110.525u
X195 xtemp__XR2F__20 xtemp__XR2F__19 VSS ppolyf_u r_width=2u r_length=110.525u
X196 xtemp__XR2F__20 xtemp__XR2F__21 VSS ppolyf_u r_width=2u r_length=110.525u
X197 xtemp__XR2F__22 xtemp__XR2F__21 VSS ppolyf_u r_width=2u r_length=110.525u
X198 xtemp__XR2F__22 xtemp__XR2F__23 VSS ppolyf_u r_width=2u r_length=110.525u
X199 xtemp__T5 xtemp__XR2F__23 VSS ppolyf_u r_width=2u r_length=110.525u
X200 xtemp__T5 xtemp__XR2T5__1 VSS ppolyf_u r_width=2u r_length=114.855u
X201 xtemp__T4 xtemp__XR2T5__1 VSS ppolyf_u r_width=2u r_length=114.855u
X202 xtemp__T4 xtemp__XR2T4__1 VSS ppolyf_u r_width=2u r_length=57.345u
X203 xtemp__T3 xtemp__XR2T4__1 VSS ppolyf_u r_width=2u r_length=57.345u
X204 xtemp__T3 xtemp__XR2T3__1 VSS ppolyf_u r_width=2u r_length=28.59u
X205 xtemp__T2 xtemp__XR2T3__1 VSS ppolyf_u r_width=2u r_length=28.59u
X206 xtemp__T2 xtemp__XR2T2__1 VSS ppolyf_u r_width=2u r_length=14.21u
X207 xtemp__T1 xtemp__XR2T2__1 VSS ppolyf_u r_width=2u r_length=14.21u
X208 xtemp__T1 xtemp__XR2T1__1 VSS ppolyf_u r_width=2u r_length=7.015u
X209 xtemp__T0 xtemp__XR2T1__1 VSS ppolyf_u r_width=2u r_length=7.015u
X210 xtemp__T0 xtemp__XR2T0__1 VSS ppolyf_u r_width=2u r_length=3.425u
X211 VSS xtemp__XR2T0__1 VSS ppolyf_u r_width=2u r_length=3.425u
X212 xcmp__SNS VDD VSS ppolyf_u_3k r_width=2u r_length=7897.44u
X213 xcmp__SNSB xcmp__SNS VSS ppolyf_u_3k r_width=2u r_length=6769.23u
X214 VSS xcmp__SNSB VSS ppolyf_u_3k r_width=2u r_length=775u
X215 VREF xbias__XR2__1 VSS ppolyf_u_3k r_width=2u r_length=256.5u
X216 xbias__XR2__2 xbias__XR2__1 VSS ppolyf_u_3k r_width=2u r_length=256.5u
X217 xbias__XR2__2 xbias__XR2__3 VSS ppolyf_u_3k r_width=2u r_length=256.5u
X218 xbias__XR2__4 xbias__XR2__3 VSS ppolyf_u_3k r_width=2u r_length=256.5u
X219 xbias__XR2__4 xbias__XR2__5 VSS ppolyf_u_3k r_width=2u r_length=256.5u
X220 xbias__XR2__6 xbias__XR2__5 VSS ppolyf_u_3k r_width=2u r_length=256.5u
X221 xbias__XR2__6 xbias__XR2__7 VSS ppolyf_u_3k r_width=2u r_length=256.5u
X222 xbias__XR2__8 xbias__XR2__7 VSS ppolyf_u_3k r_width=2u r_length=256.5u
X223 xbias__XR2__8 xbias__XR2__9 VSS ppolyf_u_3k r_width=2u r_length=256.5u
X224 xbias__XR2__10 xbias__XR2__9 VSS ppolyf_u_3k r_width=2u r_length=256.5u
X225 xbias__XR2__10 xbias__XR2__11 VSS ppolyf_u_3k r_width=2u r_length=256.5u
X226 xbias__XR2__12 xbias__XR2__11 VSS ppolyf_u_3k r_width=2u r_length=256.5u
X227 xbias__XR2__12 xbias__XR2__13 VSS ppolyf_u_3k r_width=2u r_length=256.5u
X228 xbias__XR2__14 xbias__XR2__13 VSS ppolyf_u_3k r_width=2u r_length=256.5u
X229 xbias__XR2__14 xbias__XR2__15 VSS ppolyf_u_3k r_width=2u r_length=256.5u
X230 xbias__ER xbias__XR2__15 VSS ppolyf_u_3k r_width=2u r_length=256.5u
X231 xbias__NZ xbias__XRZ__1 VSS ppolyf_u_3k r_width=2u r_length=254u
X232 xbias__XRZ__2 xbias__XRZ__1 VSS ppolyf_u_3k r_width=2u r_length=254u
X233 xbias__XRZ__2 xbias__XRZ__3 VSS ppolyf_u_3k r_width=2u r_length=254u
X234 xbias__N2 xbias__XRZ__3 VSS ppolyf_u_3k r_width=2u r_length=254u
X235 xbias__NB xbias__XR1__1 VSS ppolyf_u_3k r_width=2u r_length=175u
X236 xbias__EC xbias__XR1__1 VSS ppolyf_u_3k r_width=2u r_length=175u
X237 xbias__NBTOP xbias__XRT__1 VSS ppolyf_u_3k r_width=2u r_length=8.75u
X238 xbias__NB xbias__XRT__1 VSS ppolyf_u_3k r_width=2u r_length=8.75u

R_102 xtemp__XRZ__2 xtemp__XRZ__2__par 50.5749
C_102 xtemp__XRZ__2__par VSS 1.599507e-15
R_103 xtemp__XRZ__4 xtemp__XRZ__4__par 50.5749
C_103 xtemp__XRZ__4__par VSS 1.599507e-15
R_104 xtemp__XRZ__6 xtemp__XRZ__6__par 50.5749
C_104 xtemp__XRZ__6__par VSS 1.599507e-15
R_105 xtemp__XRZ__8 xtemp__XRZ__8__par 50.5749
C_105 xtemp__XRZ__8__par VSS 1.599507e-15
R_106 xtemp__XR2F__2 xtemp__XR2F__2__par 50.5749
C_106 xtemp__XR2F__2__par VSS 1.599507e-15
R_107 xtemp__XR2F__4 xtemp__XR2F__4__par 50.5749
C_107 xtemp__XR2F__4__par VSS 1.599507e-15
R_108 xtemp__XR2F__6 xtemp__XR2F__6__par 50.5749
C_108 xtemp__XR2F__6__par VSS 1.599507e-15
R_109 xtemp__XR2F__8 xtemp__XR2F__8__par 50.5749
C_109 xtemp__XR2F__8__par VSS 1.599507e-15
R_11 xbias__NT xbias__NT__par 4684.5858
C_11 xbias__NT__par VSS 4.9951788e-14
R_110 xtemp__XR2F__10 xtemp__XR2F__10__par 50.5749
C_110 xtemp__XR2F__10__par VSS 1.599507e-15
R_111 xtemp__XR2F__12 xtemp__XR2F__12__par 50.5749
C_111 xtemp__XR2F__12__par VSS 1.599507e-15
R_112 xtemp__XR2F__14 xtemp__XR2F__14__par 50.5749
C_112 xtemp__XR2F__14__par VSS 1.599507e-15
R_113 xtemp__XR2F__16 xtemp__XR2F__16__par 50.5749
C_113 xtemp__XR2F__16__par VSS 1.599507e-15
R_114 xtemp__XR2F__18 xtemp__XR2F__18__par 50.5749
C_114 xtemp__XR2F__18__par VSS 1.599507e-15
R_115 xtemp__XR2F__20 xtemp__XR2F__20__par 50.5749
C_115 xtemp__XR2F__20__par VSS 1.599507e-15
R_116 xtemp__XR2F__22 xtemp__XR2F__22__par 50.5749
C_116 xtemp__XR2F__22__par VSS 1.599507e-15
R_12 xbias__N1 xbias__N1__par 4967.8583
C_12 xbias__N1__par VSS 5.978126e-14
R_122 xtemp__XR2T0__1 xtemp__XR2T0__1__par 50.5749
C_122 xtemp__XR2T0__1__par VSS 1.599507e-15
R_123 xtemp__XR2T1__1 xtemp__XR2T1__1__par 50.5749
C_123 xtemp__XR2T1__1__par VSS 1.599507e-15
R_128 xtemp__XR2T2__1 xtemp__XR2T2__1__par 50.5749
C_128 xtemp__XR2T2__1__par VSS 1.599507e-15
R_13 xbias__N2 xbias__N2__par 7855.0506
C_13 xbias__N2__par VSS 8.4779094e-14
R_132 xtemp__XR2T3__1 xtemp__XR2T3__1__par 50.5749
C_132 xtemp__XR2T3__1__par VSS 1.599507e-15
R_14 xbias__TOK xbias__TOK__par 4690.5254
C_14 xbias__TOK__par VSS 5.2350545e-14
R_140 xtemp__XRISO__1 xtemp__XRISO__1__par 50.5749
C_140 xtemp__XRISO__1__par VSS 1.599507e-15
R_141 xtemp__XR2T4__1 xtemp__XR2T4__1__par 50.5749
C_141 xtemp__XR2T4__1__par VSS 1.599507e-15
R_142 xtemp__XR1__1 xtemp__XR1__1__par 50.5749
C_142 xtemp__XR1__1__par VSS 1.599507e-15
R_143 xtemp__XRZ__1 xtemp__XRZ__1__par 50.5749
C_143 xtemp__XRZ__1__par VSS 1.599507e-15
R_144 xtemp__XRZ__3 xtemp__XRZ__3__par 50.5749
C_144 xtemp__XRZ__3__par VSS 1.599507e-15
R_145 xtemp__XRZ__5 xtemp__XRZ__5__par 50.5749
C_145 xtemp__XRZ__5__par VSS 1.599507e-15
R_146 xtemp__XRZ__7 xtemp__XRZ__7__par 50.5749
C_146 xtemp__XRZ__7__par VSS 1.599507e-15
R_147 xtemp__XRZ__9 xtemp__XRZ__9__par 50.5749
C_147 xtemp__XRZ__9__par VSS 1.599507e-15
R_148 xtemp__XR2F__1 xtemp__XR2F__1__par 50.5749
C_148 xtemp__XR2F__1__par VSS 1.599507e-15
R_149 xtemp__XR2F__3 xtemp__XR2F__3__par 50.5749
C_149 xtemp__XR2F__3__par VSS 1.599507e-15
R_15 xbias__NOKO xbias__NOKO__par 4792.4183
C_15 xbias__NOKO__par VSS 5.9161863e-14
R_150 xtemp__XR2F__5 xtemp__XR2F__5__par 50.5749
C_150 xtemp__XR2F__5__par VSS 1.599507e-15
R_151 xtemp__XR2F__7 xtemp__XR2F__7__par 50.5749
C_151 xtemp__XR2F__7__par VSS 1.599507e-15
R_152 xtemp__XR2F__9 xtemp__XR2F__9__par 50.5749
C_152 xtemp__XR2F__9__par VSS 1.599507e-15
R_153 xtemp__XR2F__11 xtemp__XR2F__11__par 50.5749
C_153 xtemp__XR2F__11__par VSS 1.599507e-15
R_154 xtemp__XR2F__13 xtemp__XR2F__13__par 50.5749
C_154 xtemp__XR2F__13__par VSS 1.599507e-15
R_155 xtemp__XR2F__15 xtemp__XR2F__15__par 50.5749
C_155 xtemp__XR2F__15__par VSS 1.599507e-15
R_156 xtemp__XR2F__17 xtemp__XR2F__17__par 50.5749
C_156 xtemp__XR2F__17__par VSS 1.599507e-15
R_157 xtemp__XR2F__19 xtemp__XR2F__19__par 50.5749
C_157 xtemp__XR2F__19__par VSS 1.599507e-15
R_158 xtemp__XR2F__21 xtemp__XR2F__21__par 50.5749
C_158 xtemp__XR2F__21__par VSS 1.599507e-15
R_159 xtemp__XR2F__23 xtemp__XR2F__23__par 50.5749
C_159 xtemp__XR2F__23__par VSS 1.599507e-15
R_16 xbias__NOKL xbias__NOKL__par 4883.997
C_16 xbias__NOKL__par VSS 6.0794305e-14
R_160 xtemp__XR2T5__1 xtemp__XR2T5__1__par 50.5749
C_160 xtemp__XR2T5__1__par VSS 1.599507e-15
R_17 xbias__NKG xbias__NKG__par 4848.0503
C_17 xbias__NKG__par VSS 5.7785044e-14
R_18 xbias__NB xbias__NB__par 7667.0394
C_18 xbias__NB__par VSS 7.6118691e-14
R_19 xcmp__VDDA xcmp__VDDA__par 1263.8244
C_19 xcmp__VDDA__par VSS 1.4679011e-14
R_20 xcmp__NA xcmp__NA__par 1384.846
C_20 xcmp__NA__par VSS 1.5868526e-14
R_21 xcmp__CMPO xcmp__CMPO__par 1382.1249
C_21 xcmp__CMPO__par VSS 1.7766709e-14
R_23 xcmp__N1 xcmp__N1__par 1437.8825
C_23 xcmp__N1__par VSS 1.7866109e-14
R_24 xcmp__TN xcmp__TN__par 1261.1261
C_24 xcmp__TN__par VSS 1.3588667e-14
R_25 xcmp__SNS xcmp__SNS__par 1410.6865
C_25 xcmp__SNS__par VSS 2.5945833e-14
R_26 xcmp__NBG xcmp__NBG__par 1516.9554
C_26 xcmp__NBG__par VSS 2.1326008e-14
R_27 xcmp__SNSB xcmp__SNSB__par 1330.8009
C_27 xcmp__SNSB__par VSS 1.7531363e-14
R_28 xpor__PDN xpor__PDN__par 4872.4842
C_28 xpor__PDN__par VSS 5.6528747e-14
R_29 xpor__NDL xpor__NDL__par 4462.4943
C_29 xpor__NDL__par VSS 4.7374149e-14
R_30 xpor__NDGN xpor__NDGN__par 3937.0807
C_30 xpor__NDGN__par VSS 3.4262384e-14
R_31 xpor__PGDG xpor__PGDG__par 4189.4235
C_31 xpor__PGDG__par VSS 4.2346747e-14
R_32 xpor__PGDGB xpor__PGDGB__par 4066.8737
C_32 xpor__PGDGB__par VSS 3.8945287e-14
R_33 xpor__ND1 xpor__ND1__par 4009.3517
C_33 xpor__ND1__par VSS 3.9540693e-14
R_34 xpor__NNAND xpor__NNAND__par 3939.9598
C_34 xpor__NNAND__par VSS 3.5425418e-14
R_35 xpor__NDGP xpor__NDGP__par 3936.7209
C_35 xpor__NDGP__par VSS 3.4117005e-14
R_36 xpor__NTS xpor__NTS__par 3938.5314
C_36 xpor__NTS__par VSS 3.4848444e-14
R_37 xpor__RSTB xpor__RSTB__par 4076.1772
C_37 xpor__RSTB__par VSS 4.4255369e-14
R_39 xbias__NKM xbias__NKM__par 4876.8874
C_39 xbias__NKM__par VSS 5.7923066e-14
R_40 xbias__NOKX xbias__NOKX__par 4848.8283
C_40 xbias__NOKX__par VSS 5.9899291e-14
R_41 xbias__KS1 xbias__KS1__par 4818.8511
C_41 xbias__KS1__par VSS 5.4330567e-14
R_42 xbias__KS2 xbias__KS2__par 4819.3911
C_42 xbias__KS2__par VSS 5.4548635e-14
R_43 xbias__KS3 xbias__KS3__par 4819.931
C_43 xbias__KS3__par VSS 5.4766704e-14
R_44 xbias__KS4 xbias__KS4__par 4820.471
C_44 xbias__KS4__par VSS 5.4984773e-14
R_45 xbias__NZ xbias__NZ__par 2787.6635
C_45 xbias__NZ__par VSS 2.5602753e-14
R_46 xbias__EC xbias__EC__par 2791.7858
C_46 xbias__EC__par VSS 7.4268842e-14
R_47 xpor__NDG xpor__NDG__par 4070.5407
C_47 xpor__NDG__par VSS 3.8729499e-14
R_48 xpor__TIM xpor__TIM__par 4003.8986
C_48 xpor__TIM__par VSS 3.7357712e-14
R_49 xpor__TRIP xpor__TRIP__par 4060.1906
C_49 xpor__TRIP__par VSS 3.9480796e-14
R_54 xbias__XR2__2 xbias__XR2__2__par 18.25
C_54 xbias__XR2__2__par VSS 1.8067e-15
R_55 xbias__XR2__4 xbias__XR2__4__par 18.25
C_55 xbias__XR2__4__par VSS 1.8067e-15
R_56 xbias__XR2__6 xbias__XR2__6__par 18.25
C_56 xbias__XR2__6__par VSS 1.8067e-15
R_57 xbias__XR2__8 xbias__XR2__8__par 18.25
C_57 xbias__XR2__8__par VSS 1.8067e-15
R_58 xbias__XR2__10 xbias__XR2__10__par 18.25
C_58 xbias__XR2__10__par VSS 1.8067e-15
R_59 xbias__XR2__12 xbias__XR2__12__par 18.25
C_59 xbias__XR2__12__par VSS 1.8067e-15
R_6 xbias__PG xbias__PG__par 5084.4335
C_6 xbias__PG__par VSS 6.829458e-14
R_60 xbias__XR2__14 xbias__XR2__14__par 18.25
C_60 xbias__XR2__14__par VSS 1.8067e-15
R_61 xbias__XRZ__2 xbias__XRZ__2__par 18.25
C_61 xbias__XRZ__2__par VSS 1.8067e-15
R_62 xbias__XRT__1 xbias__XRT__1__par 18.25
C_62 xbias__XRT__1__par VSS 1.8067e-15
R_63 xbias__NA xbias__NA__par 8008.5898
C_63 xbias__NA__par VSS 8.7590412e-14
R_64 xbias__ER xbias__ER__par 2787.674
C_64 xbias__ER__par VSS 3.3170077e-14
R_66 xbias__XRZ__1 xbias__XRZ__1__par 18.25
C_66 xbias__XRZ__1__par VSS 1.8067e-15
R_67 xbias__XRZ__3 xbias__XRZ__3__par 18.25
C_67 xbias__XRZ__3__par VSS 1.8067e-15
R_68 xbias__XR1__1 xbias__XR1__1__par 18.25
C_68 xbias__XR1__1__par VSS 1.8067e-15
R_69 xbias__XR2__13 xbias__XR2__13__par 18.25
C_69 xbias__XR2__13__par VSS 1.8067e-15
R_7 xbias__NBTOP xbias__NBTOP__par 7796.7657
C_7 xbias__NBTOP__par VSS 7.8325844e-14
R_70 xbias__XR2__11 xbias__XR2__11__par 18.25
C_70 xbias__XR2__11__par VSS 1.8067e-15
R_71 xbias__XR2__1 xbias__XR2__1__par 18.25
C_71 xbias__XR2__1__par VSS 1.8067e-15
R_72 xbias__XR2__3 xbias__XR2__3__par 18.25
C_72 xbias__XR2__3__par VSS 1.8067e-15
R_73 xbias__XR2__5 xbias__XR2__5__par 18.25
C_73 xbias__XR2__5__par VSS 1.8067e-15
R_74 xbias__XR2__7 xbias__XR2__7__par 18.25
C_74 xbias__XR2__7__par VSS 1.8067e-15
R_75 xbias__XR2__9 xbias__XR2__9__par 18.25
C_75 xbias__XR2__9__par VSS 1.8067e-15
R_76 xbias__XR2__15 xbias__XR2__15__par 18.25
C_76 xbias__XR2__15__par VSS 1.8067e-15
R_8 xbias__NBG xbias__NBG__par 4871.7578
C_8 xbias__NBG__par VSS 5.5851412e-14
R_9 xbias__PB xbias__PB__par 5396.0003
C_9 xbias__PB__par VSS 7.9168117e-14
RBIAS_OK BIAS_OK BIAS_OK__par 6145.4389
CBIAS_OK BIAS_OK__par VSS 6.2768673e-14
RBIAS_OKB xcmp__BIAS_OKB xcmp__BIAS_OKB__par 1631.1837
CBIAS_OKB xcmp__BIAS_OKB__par VSS 2.1659338e-14
RCTAT CTAT CTAT__par 508.901
CCTAT CTAT__par VSS 3.2409351e-14
REN_RESETn RESETn RESETn__par 5644.0621
CEN_RESETn RESETn__par VSS 7.8040539e-14
RENB xtemp__ENB xtemp__ENB__par 1722.3174
CENB xtemp__ENB__par VSS 3.6434644e-14
RIBIAS IBIAS IBIAS__par 10641.6413
CIBIAS IBIAS__par VSS 1.22603459e-13
RM1D xtemp__M1D xtemp__M1D__par 1326.5002
CM1D xtemp__M1D__par VSS 2.6584926e-14
RM2D xtemp__M2D xtemp__M2D__par 1250.9542
CM2D xtemp__M2D__par VSS 2.5194004e-14
RM3D xtemp__M3D xtemp__M3D__par 1175.4138
CM3D xtemp__M3D__par VSS 2.3803081e-14
RN1 xtemp__N1 xtemp__N1__par 3916.0744
CN1 xtemp__N1__par VSS 3.9166451e-14
RN2 xtemp__N2 xtemp__N2__par 2349.712
CN2 xtemp__N2__par VSS 5.2203575e-14
RNA xtemp__NA xtemp__NA__par 2133.218
CNA xtemp__NA__par VSS 6.3089263e-14
RNB xtemp__NB xtemp__NB__par 2057.3709
CNB xtemp__NB__par VSS 4.3487422e-14
RNBG xtemp__NBG xtemp__NBG__par 1144.9314
CNBG xtemp__NBG__par VSS 2.6946068e-14
RNC xtemp__NC xtemp__NC__par 65.9407
CNC xtemp__NC__par VSS 8.5417204e-14
RND xtemp__ND xtemp__ND__par 1512.6715
CND xtemp__ND__par VSS 3.4769335e-14
RNR xtemp__NR xtemp__NR__par 1694.9168
CNR xtemp__NR__par VSS 3.5399052e-14
RNT xtemp__NT xtemp__NT__par 5451.5605
CNT xtemp__NT__par VSS 7.8898189e-14
RNZ xtemp__NZ xtemp__NZ__par 105.4542
CNZ xtemp__NZ__par VSS 2.9318592e-14
RPB xtemp__PB xtemp__PB__par 3535.6753
CPB xtemp__PB__par VSS 4.7145745e-14
RPCAS xtemp__PCAS xtemp__PCAS__par 4548.8647
CPCAS xtemp__PCAS__par VSS 5.3738496e-14
RPG xtemp__PG xtemp__PG__par 5100.5412
CPG xtemp__PG__par VSS 6.1711967e-14
RPOR_RAW POR_RAW POR_RAW__par 5322.6333
CPOR_RAW POR_RAW__par VSS 4.7741177e-14
RPTAT PTAT PTAT__par 962.4337
CPTAT PTAT__par VSS 3.9542032e-14
RT0 xtemp__T0 xtemp__T0__par 1253.0071
CT0 xtemp__T0__par VSS 5.5998739e-14
RT1 xtemp__T1 xtemp__T1__par 1214.9021
CT1 xtemp__T1__par VSS 5.5179431e-14
RT2 xtemp__T2 xtemp__T2__par 1176.8024
CT2 xtemp__T2__par VSS 5.4360123e-14
RT3 xtemp__T3 xtemp__T3__par 1138.7083
CT3 xtemp__T3__par VSS 5.3540815e-14
RT4 xtemp__T4 xtemp__T4__par 1100.6204
CT4 xtemp__T4__par VSS 5.2721507e-14
RT5 xtemp__T5 xtemp__T5__par 607.3914
CT5 xtemp__T5__par VSS 4.5515196e-14
RVDD VDD VDD__par 12219.9609
CVDD VDD__par VSS 3.93566639e-13
RVREF VREF VREF__par 9024.0306
CVREF VREF__par VSS 8.5089816e-14
RVSS VSS VSS__par 3386.9482
CVSS VSS__par VSS 1.829144318e-12
.ends temp_por_top
