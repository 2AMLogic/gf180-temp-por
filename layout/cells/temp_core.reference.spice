* temp_core -- klt lvs reference netlist
* generated by layout/lvs_reference.py from design/netlist/temp_core.spice
* Do not edit: edit the schematic, re-run design/netlist.py, re-run this.
.SUBCKT temp_core VSS VDD EN ENB IBIAS NBG PB PCAS NT NA NB N1 N2 PG M1D M2D M3D ND NR CTAT PTAT T5 T4 T3 T2 T1 T0 vsubs
M1 IBIAS NBG VSS vsubs nfet L=2U W=4U
M2 IBIAS EN NBG vsubs nfet L=0.5U W=2U
M3 NBG ENB VSS vsubs nfet L=0.5U W=2U
M4 PB NBG VSS vsubs nfet L=2U W=4U
M5 PB PB VDD NW1 pfet L=4U W=10U
M6 PCAS NBG VSS vsubs nfet L=2U W=4U
M7 PCAS PCAS VDD NW1 pfet L=8U W=1U
M8 ENB EN VDD NW1 pfet L=0.5U W=2U
M9 ENB EN VSS vsubs nfet L=0.5U W=1U
M10 NT PB VDD NW1 pfet L=4U W=20U
M11 N1 NA NT NW2 pfet L=4U W=16U
M12 N1 NA NT NW2 pfet L=4U W=16U
M13 N2 NB NT NW2 pfet L=4U W=16U
M14 N2 NB NT NW2 pfet L=4U W=16U
M15 N1 N1 VSS vsubs nfet L=8U W=4U
M16 N1 N1 VSS vsubs nfet L=8U W=4U
M17 N2 N1 VSS vsubs nfet L=8U W=4U
M18 N2 N1 VSS vsubs nfet L=8U W=4U
M19 PG N2 VSS vsubs nfet L=8U W=8U
M20 PG PB VDD NW1 pfet L=4U W=10U
M21 M1D PG VDD NW1 pfet L=4U W=4U
M22 M1D PG VDD NW1 pfet L=4U W=4U
M23 NA PCAS M1D NW1 pfet L=1U W=4U
M24 NA PCAS M1D NW1 pfet L=1U W=4U
M25 M2D PG VDD NW1 pfet L=4U W=4U
M26 M2D PG VDD NW1 pfet L=4U W=4U
M27 NB PCAS M2D NW1 pfet L=1U W=4U
M28 NB PCAS M2D NW1 pfet L=1U W=4U
M29 M3D PG VDD NW1 pfet L=4U W=4U
M30 M3D PG VDD NW1 pfet L=4U W=4U
M31 PTAT PCAS M3D NW1 pfet L=1U W=4U
M32 PTAT PCAS M3D NW1 pfet L=1U W=4U
M33 ND PB VDD NW1 pfet L=8U W=1U
M34 ND NR VSS vsubs nfet L=2U W=2U
M35 PG ND VSS vsubs nfet L=1U W=4U
M36 ND ENB VSS vsubs nfet L=0.5U W=2U
M37 PG EN VDD NW1 pfet L=0.5U W=4U
M38 PTAT ENB VSS vsubs nfet L=1U W=1U
M39 CTAT ENB VSS vsubs nfet L=1U W=1U
M40 NR PG VDD NW1 pfet L=4U W=1U
M41 NR NR VSS vsubs nfet L=2U W=2U
M42 N2 ENB VSS vsubs nfet L=1U W=2U
M43 NT ENB VSS vsubs nfet L=1U W=2U
M44 T5 VDD T4 vsubs nfet L=0.5U W=32U
M45 T4 VSS T3 vsubs nfet L=0.5U W=32U
M46 T3 VSS T2 vsubs nfet L=0.5U W=32U
M47 T2 VSS T1 vsubs nfet L=0.5U W=32U
M48 T1 VSS T0 vsubs nfet L=0.5U W=32U
M49 T0 VSS VSS vsubs nfet L=0.5U W=32U
MD50 NT NT NT NW2 pfet L=4U W=16U
MD51 NT NT NT NW2 pfet L=4U W=16U
MD52 VSS VSS VSS vsubs nfet L=8U W=4U
MD53 VSS VSS VSS vsubs nfet L=8U W=4U
MD54 VDD VDD VDD NW1 pfet L=4U W=4U
MD55 VDD VDD VDD NW1 pfet L=4U W=4U
.ENDS temp_core
