* por-vth ramp-rate control -- schematic @ ss/-40C/3.63V, tramp=4 ms -- GENERATED by run_ramp_rate_probe.py, do not edit
* pdk=gf180mcuD@c6d73a35f524070e85faff4a6a9eef49553ebc2b  harness=0.1.0

.param vdd_nom=3.3
.param vdd_val=3.63
.param temp_c=-40.0
.param tramp=0.004

.include "/Users/rwalters/.volare/gf180mcuD/libs.tech/ngspice/design.ngspice"
.lib "/Users/rwalters/.volare/gf180mcuD/libs.tech/ngspice/sm141064.ngspice" ss
.lib "/Users/rwalters/.volare/gf180mcuD/libs.tech/ngspice/sm141064.ngspice" res_ss
.lib "/Users/rwalters/.volare/gf180mcuD/libs.tech/ngspice/sm141064.ngspice" bjt_ss
.lib "/Users/rwalters/.volare/gf180mcuD/libs.tech/ngspice/sm141064.ngspice" diode_ss
.lib "/Users/rwalters/.volare/gf180mcuD/libs.tech/ngspice/sm141064.ngspice" moscap_ss
.lib "/Users/rwalters/.volare/gf180mcuD/libs.tech/ngspice/sm141064.ngspice" mimcap_ss

.temp -40.0
.options reltol=1e-5
.options abstol=1e-15
.options vntol=1e-9

.include "../ramp_rate_probe.spice"
.include "../../../../design/netlist/temp_por_top.spice"

.control
set numdgt=10
set noaskquit
  tran 10u 0.017
  meas tran vpor_rise find v(vdd) when v(xdut.por_raw)=1.5 rise=1
  meas tran vpor_rise_last find v(vdd) when v(xdut.por_raw)=1.5 rise=last
  meas tran vpor_fall find v(vdd) when v(xdut.por_raw)=1.5 fall=1
  meas tran vpor_fall_last find v(vdd) when v(xdut.por_raw)=1.5 fall=last
  meas tran vpor_rise_sns find v(vdd) when v(xdut.xcmp.sns)=v(xdut.vref) rise=1 td=1e-3
  meas tran vpor_fall_sns find v(vdd) when v(xdut.xcmp.sns)=v(xdut.vref) fall=1 td=0.011
  meas tran vref_settled find v(xdut.vref) at=0.0109
  meas tran ibias_settled find v(xdut.ibias) at=0.0109
  meas tran vref_up find v(xdut.vref) when v(vdd)=2.5 rise=1 td=1e-3
  meas tran sns_up find v(xdut.xcmp.sns) when v(vdd)=2.5 rise=1 td=1e-3
  meas tran vref_dn find v(xdut.vref) when v(vdd)=2.55 fall=1 td=0.011
  meas tran sns_dn find v(xdut.xcmp.sns) when v(vdd)=2.55 fall=1 td=0.011
  let m_vpor_rise_v = vpor_rise
  let m_vpor_fall_v = vpor_fall
  let m_v_hys_mv = (vpor_rise-vpor_fall)*1e3
  let m_rise_chatter_mv = (vpor_rise_last-vpor_rise)*1e3
  let m_fall_chatter_mv = (vpor_fall-vpor_fall_last)*1e3
  let m_vpor_rise_sns_v = vpor_rise_sns
  let m_vpor_fall_sns_v = vpor_fall_sns
  let m_v_hys_sns_mv = (vpor_rise_sns-vpor_fall_sns)*1e3
  let m_lag_rise_mv = (vpor_rise-vpor_rise_sns)*1e3
  let m_lag_fall_mv = (vpor_fall_sns-vpor_fall)*1e3
  let m_vref_settled_v = vref_settled
  let m_ibias_settled_v = ibias_settled
  let m_vref_err_up_mv = (vref_up-vref_settled)*1e3
  let m_vref_err_dn_mv = (vref_dn-vref_settled)*1e3
  let m_sns_err_up_mv = (sns_up-1.1538457604896)*1e3
  let m_sns_err_dn_mv = (sns_dn-1.2458358778551801)*1e3
  print m_vpor_rise_v
  print m_vpor_fall_v
  print m_v_hys_mv
  print m_rise_chatter_mv
  print m_fall_chatter_mv
  print m_vpor_rise_sns_v
  print m_vpor_fall_sns_v
  print m_v_hys_sns_mv
  print m_lag_rise_mv
  print m_lag_fall_mv
  print m_vref_settled_v
  print m_ibias_settled_v
  print m_vref_err_up_mv
  print m_vref_err_dn_mv
  print m_sns_err_up_mv
  print m_sns_err_dn_mv
.endc
.end
