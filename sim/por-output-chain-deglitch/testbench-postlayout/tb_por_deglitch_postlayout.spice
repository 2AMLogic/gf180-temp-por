* tb_por_deglitch_postlayout -- GENERATED by sim/build_tb.py
* Do not edit. Sources:
*   sim/por-output-chain-deglitch/testbench/stimulus.spice
*   layout/postlayout/por_output_chain.spice  (sha256 2722ab83a3bd292d5e206d3cad6543db15a79d66e338d8efeea338094a2c25cb)
* Regenerate with:
*   python3 sim/build_tb.py

* por-output-chain-deglitch -- stimulus half of the testbench fragment.
*
* The other half is a verbatim copy of design/netlist/por_output_chain.spice,
* appended by sim/build_tb.py to produce tb_por_deglitch.spice. Edit THIS file
* (or the schematic), never the generated fragment.
*
* Netlist FRAGMENT: no .include / .lib / .temp / .control / .end -- the
* harness owns those. Parameters it supplies: vdd_val, vdd_nom, temp_c.
*
* WHAT THIS EXPERIMENT SUBSTANTIATES
*
* spec/target-spec.md#por-brownout owns a TBD this issue has to fill: the
* deglitch dwell time, which must be <= T_dip,min for the brownout row to hold
* at all. Per DR-005 the dwell is this cell's job and is a separate,
* time-domain mechanism from the comparator's static hysteresis (#10) -- the
* two are not interchangeable and must not be double-counted.
*
* T_dip,min IS 30 us, NOT 10 us, SINCE DR-027 (#251)
*
* The 10 us this file was written against was an internal deglitch-dwell
* target, set when the cell was costed against an idealised 0.5x nominal bias.
* DR-024 measured the current the assembly really delivers to this cell
* (91.0251 nA, 0.182x nominal) and at that bias the filter does not reach its
* trip point inside 10 us at ANY of the 81 PVT points. DR-027 (ratified
* 2026-08-11, operator, #236) re-costs T_dip,min to the dwell the cell
* actually achieves there; #251 measured it with control/run_dwell_sweep.py:
*
*   slowest crossing, stress bias, 81 points x both netlist levels
*                                          23.110 us  (ss/-40C/3.63V, schematic)
*   T_dip,min(new), by the rule fixed in that script
*   (smallest multiple of 5 us >= 1.10x the slowest)      30 us  (+29.8 %)
*
* No point failed to trip at any dwell -- control/dwell_results.md shows all
* 324 (point, netlist, bias) probe runs crossing well inside a 600 us dip --
* so DR-027 section 5's contingency (a corner with an asymptotic floor above
* trip, which no re-cost could fix) is not triggered.
*
* Three things are measured, all on the same run:
*
*   1. DWELL. POR_RAW falls; how long until RESETn is asserted again? That is
*      the deglitch dwell plus a few ns of logic, and it is what T_dip,min has
*      to exceed. Measured end-to-end at the pin on xdut1, and also at the
*      internal PGDG node so the dwell can be attributed to the filter rather
*      than to the rest of the chain.
*   2. QUALIFYING-DIP CAPTURE. The dip used for (1) is exactly 30 us -- the
*      spec's own T_dip,min, post-DR-027 -- not a comfortable long one. A dwell
*      that is nominally under 30 us but creeps over it at a corner shows up
*      here as a RESETn that never reaches a valid low, which the vmin check
*      catches. On the stress DUT the dwell itself is also published as
*      dwell_pgdg_stress_us, so the record carries the measured per-corner
*      number the bound was cut from, not only the pass/fail against it.
*   3. NO EARLY / DOUBLE PULSE. Sub-dwell chatter on POR_RAW is applied twice:
*      once while RESETn is asserted (must not restart or truncate the pulse,
*      and must not produce an early release) and once after it has released
*      (must not produce a spurious re-assertion). This is the "POR_RAW
*      chatters near threshold before the deglitch settles" edge case.
*   4. REJECTION-WIDTH MARGIN (#200). A THIRD chatter burst, 1.05 us wide --
*      5 % wider than the 1 us the checks above use -- is applied after the
*      qualifying dip has restarted the pulse. Its job is to put a number on
*      how much width margin the filter has left, at every one of the 81 PVT
*      points, instead of only asserting that one width is rejected. What it
*      measures is the one-shot's own charge (TIM before vs. its minimum over
*      the burst), because losing timer charge -- XMDIS conducting and the
*      reset pulse restarting -- is the functional failure; PGDG merely
*      drooping is not.
*
*      WHY 1.05 us. control/width_results.md walks the glitch width at the two
*      fastest corners and brackets the post-layout netlist's rejection ceiling
*      between 1.0 us (rejected) and 1.25 us (disturbed) -- the schematic's
*      bracket is 1.75 / 2.0 us. 1.05 us is inside that bracket: wider than the
*      burst the checks above use, and still a width the design AS DRAWN
*      rejects at every one of the 81 points, which is what makes it a check
*      rather than a known failure. The control answers this at two corners
*      and is overwritten on every run; this burst carries the same question
*      onto the corner grid, where the answer is recorded append-only.
*
*      It sits AFTER every other measurement window on purpose: nothing in
*      this stimulus changes before 12.99 ms, so every measurement that
*      existed before it did is bit-identical to a run without it (verified
*      across all 81 points, both netlists) and the records stay comparable.
*      #251's re-cut of the qualifying dip from 10 us to 30 us moved this
*      burst 20 us later with it, so its offset from the pulse restart stays
*      exactly the 1.0/1.1/1.2 ms the paragraph above depends on; every
*      measurement window in tb.json still brackets it unchanged.
*
* TWO DUTS, BECAUSE THE DWELL SCALES AS 1/IBIAS
*
*   xdut1  IBIAS = 0.5 uA       DR-005 nominal. Carries the end-to-end RESETn
*                               measurements, which need a prior release and
*                               therefore a timer that finishes in time.
*   xdut2  IBIAS = 91.0251 nA   the stress case for the dwell bound, since
*                               less bias current means a slower filter. This
*                               is the arm T_dip,min itself is cut from (see
*                               the DR-027 block above), so its dwell is now
*                               published per corner as dwell_pgdg_stress_us
*                               as well as being checked as a voltage floor.
*                               Re-cut by issue #221 from an idealised 0.5x
*                               nominal (0.25 uA) to the worst-case CURRENT
*                               THE ASSEMBLY ACTUALLY DELIVERS to this cell's
*                               own IBIAS pin: 0.182x nominal, measured across
*                               the full 81-point PVT grid in BOTH RESETn
*                               states by sim/por-output-chain-ibias-sharing/
*                               (bias_core sharing the node with a possibly-
*                               enabled temp_core and por_comparator, per
*                               DR-010). The binding point is RESETn
*                               RELEASED, ss/-40C/2.97V, post-layout record
*                               sim/por-output-chain-ibias-sharing/records/
*                               20260811-142901-d43c0db.md (91.0251 nA; the
*                               schematic-level record beside it,
*                               20260811-142426-a9cdd7f.md, puts its own worst
*                               point at 91.0761 nA -- not materially
*                               different, and
*                               design/por_output_chain.md's own "XMBD/IBIAS
*                               watch item" already confirms the extraction
*                               adds no series impedance on this path). This
*                               is a single FIXED value applied uniformly
*                               across the whole PVT grid, exactly as the
*                               idealised 0.25 uA it replaces was -- the
*                               worst-case *delivered* current, not a
*                               per-corner-matched one; see
*                               design/por_output_chain.md's "Hand-off to
*                               #11" section for why this is the correct
*                               stress direction. Its timer takes far longer
*                               than xdut1's to finish, so only its internal
*                               PGDG dwell is asserted on; that is the filter
*                               output and is the number the spec row
*                               actually constrains. The measurement it is
*                               asserted on CHANGES NAME with this re-cut:
*                               dwell_pgdg_halfib_us (a WHEN-based crossing
*                               TIME) becomes pgdg_min_during_halfib_dip_v (a
*                               voltage floor sampled over the qualifying dip
*                               itself), because at this current the filter is
*                               frequently too slow to trip at all inside the
*                               dip and a crossing-time measure errors out of
*                               its search interval rather than reporting the
*                               FAIL. Records minted before this commit carry
*                               the old key; they are not edited, and both
*                               keys mean "the dwell against T_dip,min on the
*                               stress DUT". The "halfib" in the new key is
*                               likewise historical -- the leg is no longer
*                               literally half nominal. Since #251 the
*                               crossing-time measure is BACK alongside it, as
*                               dwell_pgdg_stress_us: at the re-cost T_dip,min
*                               of 30 us the crossing lands inside the dip at
*                               every one of the 81 points on both netlists
*                               (6.14-23.11 us, control/dwell_results.md), so
*                               it no longer errors out of its interval, and
*                               the record needs the dwell itself -- not only
*                               its pass/fail -- to show what margin the bound
*                               was cut with.
*
* TIMELINE
*
*   0     -> 100 us   VDD ramps 0 -> vdd_val. POR_RAW low.
*   300 us            POR_RAW high: release conditions met, both timers start.
*   1.0 / 1.1 / 1.2 ms  three 1 us LOW glitches on POR_RAW, DURING assertion.
*   (<=10 ms)         xdut1 releases -- once.
*   11.0 / 11.1 / 11.2 ms  three 1 us LOW glitches, AFTER release.
*   12.0 ms           POR_RAW low for exactly 30 us: the qualifying brownout
*                     dip of the por-brownout row, at DR-027's re-cost
*                     T_dip,min. RESETn must re-assert and the full pulse must
*                     regenerate.
*   13.02 / 13.12 / 13.22 ms  three 1.05 us LOW glitches, DURING the regenerated
*                     pulse -- placed at the same 1.0/1.1/1.2 ms offset from
*                     the restart at 12.03 ms that the first battery has from
*                     the start at 300.1 us, so the one-shot is charging
*                     steadily in both, the same regime. The regenerated pulse
*                     is >4 ms at every corner recorded so far, so RESETn is
*                     still asserted throughout this burst.
*   13.6 ms           end.

vsup vdd 0 PWL(0 0 100u {vdd_val} 14m {vdd_val})

* POR_RAW: high from 300 us, with three batteries of sub-dwell chatter (two at
* 1 us, one at 1.05 us) and one 30 us qualifying dip. Edges are 100 ns so the
* glitches are genuinely as wide at the pin as they are drawn here rather than
* being softened into nothing by the source.
vpr por_raw 0 PWL(0 0
+ 300u 0 300.1u {vdd_val}
+ 999.9u {vdd_val} 1000u 0 1001u 0 1001.1u {vdd_val}
+ 1099.9u {vdd_val} 1100u 0 1101u 0 1101.1u {vdd_val}
+ 1199.9u {vdd_val} 1200u 0 1201u 0 1201.1u {vdd_val}
+ 10999.9u {vdd_val} 11000u 0 11001u 0 11001.1u {vdd_val}
+ 11099.9u {vdd_val} 11100u 0 11101u 0 11101.1u {vdd_val}
+ 11199.9u {vdd_val} 11200u 0 11201u 0 11201.1u {vdd_val}
+ 11999.9u {vdd_val} 12000u 0 12030u 0 12030.1u {vdd_val}
+ 13019.9u {vdd_val} 13020u 0 13021.05u 0 13021.15u {vdd_val}
+ 13119.9u {vdd_val} 13120u 0 13121.05u 0 13121.15u {vdd_val}
+ 13219.9u {vdd_val} 13220u 0 13221.05u 0 13221.15u {vdd_val}
+ 14m {vdd_val})

Bib1 vdd nib1 i='500n*min(1, max(0, (v(vdd)-1.5)/0.5))'
vib1 nib1 ibias1 dc 0
Bib2 vdd nib2 i='91.0251n*min(1, max(0, (v(vdd)-1.5)/0.5))'
vib2 nib2 ibias2 dc 0

vd1 vdd vdd1 dc 0
vd2 vdd vdd2 dc 0

Cl1 resetn1 0 5p
Rl1 resetn1 0 1T
Cl2 resetn2 0 5p
Rl2 resetn2 0 1T

xdut1 vdd1 0 ibias1 por_raw resetn1 por_output_chain
xdut2 vdd2 0 ibias2 por_raw resetn2 por_output_chain

* por_output_chain -- post-layout netlist
* GENERATED by layout/postlayout.py -- do not edit.
*
* FROM THE LAYOUT: every device and its dimensions, the whole
*   topology, and first-order interconnect R/C on 18/30 nets
*   (sigma 828.6 fF). klt 0.2.0, deck gf180mcu,
*   GDS sha256 475c7feaa83591e1...
* Net names are the schematic's, restored through klt lvs's own net
*   correspondence -- match, 30/30 nets, every one paired.
*
* NOT FROM THE LAYOUT -- see layout/postlayout/AUDIT.md:
*   12 body/plate net(s) tied to the net the schematic puts
*   them on. The extraction deck's connectivity stack does not reach
*   an Nwell, a substrate ring, a bipolar base well or a MiM plate,
*   so they extract isolated and would otherwise float.
*   No ideal device: every golden device is drawn.
*
.subckt por_output_chain VDD VSS IBIAS POR_RAW RESETn

* --- drawn devices ---
X1 PDN IBIAS VSS VSS nfet_03v3 L=25u W=0.5u nf=1 ad=0.4p as=0.4p pd=2.6u ps=2.6u m=1
X2 PGDGB PGDG VSS VSS nfet_03v3 L=2u W=0.5u nf=1 ad=0.4p as=0.4p pd=2.6u ps=2.6u m=1
X3 ND1 NDL VSS VSS nfet_03v3 L=10u W=0.5u nf=1 ad=0.4p as=0.4p pd=2.6u ps=2.6u m=1
X4 NDG POR_RAW NDGN VSS nfet_03v3 L=0.5u W=1u nf=1 ad=0.8p as=0.8p pd=3.6u ps=3.6u m=1
X5 TIM PGDGB VSS VSS nfet_03v3 L=1u W=1u nf=1 ad=0.8p as=0.8p pd=3.6u ps=3.6u m=1
X6 TRIP ND1 VSS VSS nfet_03v3 L=1u W=1u nf=1 ad=0.8p as=0.8p pd=3.6u ps=3.6u m=1
X7 ND1 RESETn VSS VSS nfet_03v3 L=1u W=1u nf=1 ad=0.8p as=0.8p pd=3.6u ps=3.6u m=1
X8 NDL NDL VSS VSS nfet_03v3 L=10u W=2u nf=1 ad=1.6p as=1.6p pd=5.6u ps=5.6u m=1
X9 PGDG NDG VSS VSS nfet_03v3 L=0.5u W=2u nf=1 ad=1.6p as=1.6p pd=5.6u ps=5.6u m=1
X10 RSTB TRIP NNAND VSS nfet_03v3 L=0.5u W=2u nf=1 ad=1.6p as=1.6p pd=5.6u ps=5.6u m=1
X11 NNAND PGDG VSS VSS nfet_03v3 L=0.5u W=2u nf=1 ad=1.6p as=1.6p pd=5.6u ps=5.6u m=1
X12 IBIAS IBIAS VSS VSS nfet_03v3 L=4u W=4u nf=1 ad=3.2p as=3.2p pd=9.6u ps=9.6u m=1
X13 NDGN NDL VSS VSS nfet_03v3 L=10u W=10u nf=1 ad=8p as=8p pd=21.6u ps=21.6u m=1
X14 RESETn RSTB VSS VSS nfet_03v3 L=0.5u W=10u nf=1 ad=8p as=8p pd=21.6u ps=21.6u m=1
X15 NTS PDN VDD VDD pfet_03v3 L=10u W=0.5u nf=1 ad=0.4p as=0.4p pd=2.6u ps=2.6u m=1
X16 TRIP PDN VDD VDD pfet_03v3 L=10u W=0.5u nf=1 ad=0.4p as=0.4p pd=2.6u ps=2.6u m=1
X17 PGDG NDG VDD VDD pfet_03v3 L=2u W=0.5u nf=1 ad=0.4p as=0.4p pd=2.6u ps=2.6u m=1
X18 RSTB RESETn VDD VDD pfet_03v3 L=10u W=0.5u nf=1 ad=0.4p as=0.4p pd=2.6u ps=2.6u m=1
X19 NDG POR_RAW NDGP VDD pfet_03v3 L=0.5u W=1u nf=1 ad=0.8p as=0.8p pd=3.6u ps=3.6u m=1
X20 RESETn RSTB VDD VDD pfet_03v3 L=1u W=1u nf=1 ad=0.8p as=0.8p pd=3.6u ps=3.6u m=1
X21 PDN PDN VDD VDD pfet_03v3 L=10u W=2u nf=1 ad=1.6p as=1.6p pd=5.6u ps=5.6u m=1
X22 NDL PDN VDD VDD pfet_03v3 L=10u W=2u nf=1 ad=1.6p as=1.6p pd=5.6u ps=5.6u m=1
X23 PGDGB PGDG VDD VDD pfet_03v3 L=0.5u W=2u nf=1 ad=1.6p as=1.6p pd=5.6u ps=5.6u m=1
X24 TIM PGDGB NTS VDD pfet_03v3 L=1u W=2u nf=1 ad=1.6p as=1.6p pd=5.6u ps=5.6u m=1
X25 ND1 TIM VDD VDD pfet_03v3 L=1u W=2u nf=1 ad=1.6p as=1.6p pd=5.6u ps=5.6u m=1
X26 RSTB TRIP VDD VDD pfet_03v3 L=0.5u W=4u nf=1 ad=3.2p as=3.2p pd=9.6u ps=9.6u m=1
X27 RSTB PGDG VDD VDD pfet_03v3 L=0.5u W=4u nf=1 ad=3.2p as=3.2p pd=9.6u ps=9.6u m=1
X28 NDGP PDN VDD VDD pfet_03v3 L=10u W=10u nf=1 ad=8p as=8p pd=21.6u ps=21.6u m=1
X29 NDG VSS cap_mim_2f0_m3m4_noshield c_width=11u c_length=11u
X30 TIM VSS cap_mim_2f0_m3m4_noshield c_width=28u c_length=28u
X31 TIM VSS cap_mim_2f0_m3m4_noshield c_width=28u c_length=28u
X32 TIM VSS cap_mim_2f0_m3m4_noshield c_width=28u c_length=28u
X33 TIM VSS cap_mim_2f0_m3m4_noshield c_width=28u c_length=28u

R_10 NDGN NDGN__par 3937.0807
C_10 NDGN__par VSS 3.4262384e-14
R_11 NDG NDG__par 4070.1194
C_11 NDG__par VSS 3.8582127e-14
R_12 PGDG PGDG__par 4189.4122
C_12 PGDG__par VSS 4.2342204e-14
R_13 TIM TIM__par 4003.4777
C_13 TIM__par VSS 3.7210339e-14
R_14 TRIP TRIP__par 4060.1793
C_14 TRIP__par VSS 3.9476253e-14
R_15 NNAND NNAND__par 3939.9598
C_15 NNAND__par VSS 3.5425418e-14
R_16 NDGP NDGP__par 3936.7209
C_16 NDGP__par VSS 3.4117005e-14
R_17 RSTB RSTB__par 4076.1659
C_17 RSTB__par VSS 4.4250826e-14
R_2 PDN PDN__par 4872.473
C_2 PDN__par VSS 5.6524204e-14
R_3 NDL NDL__par 4462.4943
C_3 NDL__par VSS 4.7374149e-14
R_5 PGDGB PGDGB__par 4066.8624
C_5 PGDGB__par VSS 3.8940744e-14
R_6 ND1 ND1__par 4009.3404
C_6 ND1__par VSS 3.953615e-14
R_8 NTS NTS__par 3938.5202
C_8 NTS__par VSS 3.4843901e-14
RIBIAS IBIAS IBIAS__par 4398.6611
CIBIAS IBIAS__par VSS 4.5280553e-14
RPOR_RAW POR_RAW POR_RAW__par 4047.2842
CPOR_RAW POR_RAW__par VSS 3.435215e-14
RRESETn RESETn RESETn__par 4167.0798
CRESETn RESETn__par VSS 4.4306787e-14
RVDD VDD VDD__par 79.7582
CVDD VDD__par VSS 6.9000979e-14
RVSS VSS VSS__par 66.7327
CVSS VSS__par VSS 1.12754344e-13
.ends por_output_chain
