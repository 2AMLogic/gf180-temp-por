* tb_por_pulse_postlayout -- GENERATED by sim/build_tb.py
* Do not edit. Sources:
*   sim/por-output-chain-pulse/testbench/stimulus.spice
*   layout/postlayout/por_output_chain.spice  (sha256 3d6e84ccb08651c7d07e9b343a937b64b2395f0860b677fdb88eb017a062f3a5)
* Regenerate with:
*   python3 sim/build_tb.py

* por-output-chain-pulse -- stimulus half of the testbench fragment.
*
* The other half is a verbatim copy of design/netlist/por_output_chain.spice,
* appended by sim/build_tb.py to produce tb_por_pulse.spice. Edit THIS file
* (or the schematic), never the generated fragment.
*
* Netlist FRAGMENT: no .include / .lib / .temp / .control / .end -- the
* harness owns those. Parameters it supplies: vdd_val, vdd_nom, temp_c.
*
* WHAT THIS EXPERIMENT SUBSTANTIATES
*
* spec/target-spec.md#por-reset-pulse: RESETn stays asserted for >=1 ms after
* the release conditions are met, at the FASTEST-timer corner. The pulse here
* is a current-starved ramp (2.5 nA into 6.27 pF), so "fastest" is the corner
* with the most charging current and the least capacitance -- FF / +125 C /
* 3.63 V -- and the whole 81-point grid is swept to prove that is really where
* the minimum lands rather than assuming it.
*
* It also records this cell's share of the shared spec/target-spec.md#por-iq
* budget, sampled in the state that row is defined in (rule 1 of the table's
* section 5): RESETn asserted, rail settled, sensor disabled.
*
* THE IBIAS TOLERANCE PROBLEM, AND WHY THERE ARE TWO DUTS
*
* Every internal current in this cell is a ratio of IBIAS, so the pulse width
* scales as 1/IBIAS. bias_core (#11) has not landed, so its corner spread is
* not yet knowable; asserting >=1 ms against one ideal 0.5 uA source would be
* a result that #11 could silently invalidate later. Instead two identical
* DUTs run side by side on the same rail:
*
*   xdut1  IBIAS = 0.5 uA   the DR-005 nominal (same convention as temp_core:
*                           bias_core SOURCES the current into the pin)
*   xdut2  IBIAS = 1.5 uA   3x nominal -- the stress case for the >=1 ms
*                           minimum, since more bias current means a faster
*                           timer. If xdut2 clears 1 ms at every corner then
*                           the claim survives a 3x IBIAS error from #11.
*
* TIMELINE
*
*   0     -> 100 us   VDD ramps 0 -> vdd_val (~33 kV/s, inside the ratified
*                     por-ramp-rate envelope). POR_RAW held low.
*   100 us-> 1 ms     rail settled, POR_RAW low: this is exactly the por-iq
*                     accounting state. Sampled at 0.9 ms.
*   1.001 ms          POR_RAW steps high -- the release condition. Stepping it
*                     rather than deriving it from the ramp is deliberate: the
*                     pulse is measured from a single unambiguous t0, and
*                     ramp-crossing behaviour is #14's job, not this record's.
*   ...               RESETn must stay low for >=1 ms, then release once.
*   19.5 ms           released-state draw sampled (feeds iq-total, not por-iq)

vsup vdd 0 PWL(0 0 100u {vdd_val} 20m {vdd_val})
vpr  por_raw 0 PWL(0 0 1m 0 1.002m {vdd_val} 20m {vdd_val})

* IBIAS references. Modelled as coming up with the rail rather than as ideal
* DC sources: below ~1.5 V there is no bias core yet (DR-005 startup ordering
* step 3), so forcing current into the pin while the rail is dead would be a
* stimulus artefact. Same construction as sim/temp-core-startup/.
Bib1 vdd nib1 i='500n*min(1, max(0, (v(vdd)-1.5)/0.5))'
vib1 nib1 ibias1 dc 0
Bib2 vdd nib2 i='1500n*min(1, max(0, (v(vdd)-1.5)/0.5))'
vib2 nib2 ibias2 dc 0

* 0 V ammeters in each DUT's own VDD pin. The IBIAS reference is sourced from
* vdd directly, so it does NOT pass through these -- i(vd1) is what this cell
* draws from the rail on its own account, which is the number the por-iq
* budget needs.
vd1 vdd vdd1 dc 0
vd2 vdd vdd2 dc 0

* por-reset-pulse measurement load, provisional per the spec row: 5 pF, no DC
* load. The 1 Tohm is a solver aid, not a load.
Cl1 resetn1 0 5p
Rl1 resetn1 0 1T
Cl2 resetn2 0 5p
Rl2 resetn2 0 1T

xdut1 vdd1 0 ibias1 por_raw resetn1 por_output_chain
xdut2 vdd2 0 ibias2 por_raw resetn2 por_output_chain

* por_output_chain -- post-layout netlist
* GENERATED by layout/postlayout.py -- do not edit.
*
* FROM THE LAYOUT: every device and its dimensions, the whole
*   topology, and first-order interconnect R/C on 18/18 nets
*   (sigma 901.4 fF, of which 81.195 fF is net-to-net coupling).
*   One star per net: <net> is the hub, <net>__t<k> each device
*   terminal on it, R<net>_t<k> the arm between them.
*   klt 0.6.0, deck gf180mcu,
*   GDS sha256 79a1439bdf87109c...
* Net names are the schematic's, restored through klt lvs's own net
*   correspondence -- match, 18/18 nets, every one paired.
*
* NOT FROM THE LAYOUT -- see layout/postlayout/AUDIT.md:
*   2 body/plate net(s) tied to the net the schematic puts
*   them on. The extraction deck's connectivity stack does not reach
*   an Nwell, a substrate ring, a bipolar base well or a MiM plate,
*   so they extract isolated and would otherwise float.
*   No ideal device: every golden device is drawn.
*
.subckt por_output_chain VDD VSS IBIAS POR_RAW RESETn

* --- drawn devices ---
X1 PDN__t0 IBIAS__t0 VSS__t0 VSS__t17 nfet_03v3 L=25u W=0.5u nf=1 ad=0.4p as=0.4p pd=2.6u ps=2.6u m=1
X2 PGDGB__t2 PGDG__t3 VSS__t1 VSS__t18 nfet_03v3 L=2u W=0.5u nf=1 ad=0.4p as=0.4p pd=2.6u ps=2.6u m=1
X3 ND1__t1 NDL__t0 VSS__t2 VSS__t19 nfet_03v3 L=10u W=0.5u nf=1 ad=0.4p as=0.4p pd=2.6u ps=2.6u m=1
X4 NDG__t2 POR_RAW__t1 NDGN__t0 VSS__t20 nfet_03v3 L=0.5u W=1u nf=1 ad=0.8p as=0.8p pd=3.6u ps=3.6u m=1
X5 TIM__t4 PGDGB__t3 VSS__t3 VSS__t21 nfet_03v3 L=1u W=1u nf=1 ad=0.8p as=0.8p pd=3.6u ps=3.6u m=1
X6 TRIP__t3 ND1__t3 VSS__t16 VSS__t22 nfet_03v3 L=1u W=1u nf=1 ad=0.8p as=0.8p pd=3.6u ps=3.6u m=1
X7 ND1__t2 RESETn__t2 VSS__t15 VSS__t23 nfet_03v3 L=1u W=1u nf=1 ad=0.8p as=0.8p pd=3.6u ps=3.6u m=1
X8 NDL__t1 NDL__t2 VSS__t4 VSS__t24 nfet_03v3 L=10u W=2u nf=1 ad=1.6p as=1.6p pd=5.6u ps=5.6u m=1
X9 PGDG__t4 NDG__t3 VSS__t5 VSS__t25 nfet_03v3 L=0.5u W=2u nf=1 ad=1.6p as=1.6p pd=5.6u ps=5.6u m=1
X10 RSTB__t4 TRIP__t1 NNAND__t1 VSS__t26 nfet_03v3 L=0.5u W=2u nf=1 ad=1.6p as=1.6p pd=5.6u ps=5.6u m=1
X11 NNAND__t0 PGDG__t5 VSS__t14 VSS__t27 nfet_03v3 L=0.5u W=2u nf=1 ad=1.6p as=1.6p pd=5.6u ps=5.6u m=1
X12 IBIAS__t1 IBIAS__t2 VSS__t6 VSS__t28 nfet_03v3 L=4u W=4u nf=1 ad=3.2p as=3.2p pd=9.6u ps=9.6u m=1
X13 NDGN__t1 NDL__t3 VSS__t7 VSS__t29 nfet_03v3 L=10u W=10u nf=1 ad=8p as=8p pd=21.6u ps=21.6u m=1
X14 RESETn__t0 RSTB__t0 VSS__t8 VSS__t30 nfet_03v3 L=0.5u W=10u nf=1 ad=8p as=8p pd=21.6u ps=21.6u m=1
X15 NTS__t0 PDN__t1 VDD__t0 VDD__t1 pfet_03v3 L=10u W=0.5u nf=1 ad=0.4p as=0.4p pd=2.6u ps=2.6u m=1
X16 TRIP__t2 PDN__t6 VDD__t25 VDD__t23 pfet_03v3 L=10u W=0.5u nf=1 ad=0.4p as=0.4p pd=2.6u ps=2.6u m=1
X17 PGDG__t0 NDG__t0 VDD__t2 VDD__t3 pfet_03v3 L=2u W=0.5u nf=1 ad=0.4p as=0.4p pd=2.6u ps=2.6u m=1
X18 RSTB__t5 RESETn__t3 VDD__t24 VDD__t22 pfet_03v3 L=10u W=0.5u nf=1 ad=0.4p as=0.4p pd=2.6u ps=2.6u m=1
X19 NDG__t1 POR_RAW__t0 NDGP__t0 VDD__t4 pfet_03v3 L=0.5u W=1u nf=1 ad=0.8p as=0.8p pd=3.6u ps=3.6u m=1
X20 RESETn__t1 RSTB__t1 VDD__t5 VDD__t6 pfet_03v3 L=1u W=1u nf=1 ad=0.8p as=0.8p pd=3.6u ps=3.6u m=1
X21 PDN__t2 PDN__t3 VDD__t7 VDD__t8 pfet_03v3 L=10u W=2u nf=1 ad=1.6p as=1.6p pd=5.6u ps=5.6u m=1
X22 NDL__t4 PDN__t5 VDD__t21 VDD__t20 pfet_03v3 L=10u W=2u nf=1 ad=1.6p as=1.6p pd=5.6u ps=5.6u m=1
X23 PGDGB__t0 PGDG__t1 VDD__t9 VDD__t10 pfet_03v3 L=0.5u W=2u nf=1 ad=1.6p as=1.6p pd=5.6u ps=5.6u m=1
X24 TIM__t5 PGDGB__t1 NTS__t1 VDD__t11 pfet_03v3 L=1u W=2u nf=1 ad=1.6p as=1.6p pd=5.6u ps=5.6u m=1
X25 ND1__t0 TIM__t6 VDD__t12 VDD__t19 pfet_03v3 L=1u W=2u nf=1 ad=1.6p as=1.6p pd=5.6u ps=5.6u m=1
X26 RSTB__t2 TRIP__t0 VDD__t13 VDD__t14 pfet_03v3 L=0.5u W=4u nf=1 ad=3.2p as=3.2p pd=9.6u ps=9.6u m=1
X27 RSTB__t3 PGDG__t2 VDD__t18 VDD__t17 pfet_03v3 L=0.5u W=4u nf=1 ad=3.2p as=3.2p pd=9.6u ps=9.6u m=1
X28 NDGP__t1 PDN__t4 VDD__t15 VDD__t16 pfet_03v3 L=10u W=10u nf=1 ad=8p as=8p pd=21.6u ps=21.6u m=1
X29 NDG__t4 VSS__t9 cap_mim_2f0_m3m4_noshield c_width=11u c_length=11u
X30 TIM__t0 VSS__t10 cap_mim_2f0_m3m4_noshield c_width=28u c_length=28u
X31 TIM__t3 VSS__t13 cap_mim_2f0_m3m4_noshield c_width=28u c_length=28u
X32 TIM__t2 VSS__t12 cap_mim_2f0_m3m4_noshield c_width=28u c_length=28u
X33 TIM__t1 VSS__t11 cap_mim_2f0_m3m4_noshield c_width=28u c_length=28u

R_10_t0 NDGN__t0 NDGN 1968.54035
R_10_t1 NDGN__t1 NDGN 1968.54035
C_10 NDGN VSS 3.4262384e-14
R_11_t0 NDG__t0 NDG 1014.07506597
R_11_t1 NDG__t1 NDG 954.603905263
R_11_t2 NDG__t2 NDG 719.797860447
R_11_t3 NDG__t3 NDG 671.322091399
R_11_t4 NDG__t4 NDG 740.648776922
C_11 NDG VSS 5.2682676e-14
R_12_t0 PGDG__t0 PGDG 602.446318769
R_12_t1 PGDG__t1 PGDG 654.828626133
R_12_t2 PGDG__t2 PGDG 837.510194981
R_12_t3 PGDG__t3 PGDG 818.584937735
R_12_t4 PGDG__t4 PGDG 870.985079265
R_12_t5 PGDG__t5 PGDG 405.068343117
C_12 PGDG VSS 4.2322747e-14
R_13_t0 TIM__t0 TIM 550.192925008
R_13_t1 TIM__t1 TIM 450.44845788
R_13_t2 TIM__t2 TIM 646.825671411
R_13_t3 TIM__t3 TIM 295.351686536
R_13_t4 TIM__t4 TIM 305.553184754
R_13_t5 TIM__t5 TIM 892.679198138
R_13_t6 TIM__t6 TIM 921.604176272
C_13 TIM VSS 8.4756315e-14
R_14_t0 TRIP__t0 TRIP 1336.10142733
R_14_t1 TRIP__t1 TRIP 928.634222318
R_14_t2 TRIP__t2 TRIP 694.201632009
R_14_t3 TRIP__t3 TRIP 1101.25331834
C_14 TRIP VSS 3.9432796e-14
R_15_t0 NNAND__t0 NNAND 1969.9799
R_15_t1 NNAND__t1 NNAND 1969.9799
C_15 NNAND VSS 3.5401418e-14
R_16_t0 NDGP__t0 NDGP 1968.36045
R_16_t1 NDGP__t1 NDGP 1968.36045
C_16 NDGP VSS 3.4117005e-14
R_17_t0 RSTB__t0 RSTB 754.19830579
R_17_t1 RSTB__t1 RSTB 577.101205748
R_17_t2 RSTB__t2 RSTB 125.223191397
R_17_t3 RSTB__t3 RSTB 198.604997756
R_17_t4 RSTB__t4 RSTB 2034.86326663
R_17_t5 RSTB__t5 RSTB 386.186232677
C_17 RSTB VSS 4.4183369e-14
R_2_t0 PDN__t0 PDN 2192.18513758
R_2_t1 PDN__t1 PDN 753.814003433
R_2_t2 PDN__t2 PDN 119.940253161
R_2_t3 PDN__t3 PDN 119.940253161
R_2_t4 PDN__t4 PDN 470.418947224
R_2_t5 PDN__t5 PDN 171.383237922
R_2_t6 PDN__t6 PDN 1044.80236751
C_2 PDN VSS 5.6528747e-14
R_3_t0 NDL__t0 NDL 418.160636306
R_3_t1 NDL__t1 NDL 878.61286536
R_3_t2 NDL__t2 NDL 878.61286536
R_3_t3 NDL__t3 NDL 479.294941313
R_3_t4 NDL__t4 NDL 1807.81299166
C_3 NDL VSS 4.7374149e-14
R_5_t0 PGDGB__t0 PGDGB 985.115471459
R_5_t1 PGDGB__t1 PGDGB 1048.31915217
R_5_t2 PGDGB__t2 PGDGB 1055.41000903
R_5_t3 PGDGB__t3 PGDGB 978.029067333
C_5 PGDGB VSS 3.8921287e-14
R_6_t0 ND1__t0 ND1 2004.66951985
R_6_t1 ND1__t1 ND1 851.440640246
R_6_t2 ND1__t2 ND1 526.661303231
R_6_t3 ND1__t3 ND1 626.580236676
C_6 ND1 VSS 3.9492693e-14
R_8_t0 NTS__t0 NTS 1969.2657
R_8_t1 NTS__t1 NTS 1969.2657
C_8 NTS VSS 3.4836444e-14
RIBIAS_t0 IBIAS__t0 IBIAS 2199.33055
RIBIAS_t1 IBIAS__t1 IBIAS 1099.665275
RIBIAS_t2 IBIAS__t2 IBIAS 1099.665275
CIBIAS IBIAS VSS 4.5280553e-14
RPOR_RAW_t0 POR_RAW__t0 POR_RAW 2023.6421
RPOR_RAW_t1 POR_RAW__t1 POR_RAW 2023.6421
CPOR_RAW POR_RAW VSS 3.435215e-14
RRESETn_t0 RESETn__t0 RESETn 883.591221836
RRESETn_t1 RESETn__t1 RESETn 700.167162863
RRESETn_t2 RESETn__t2 RESETn 2080.85833879
RRESETn_t3 RESETn__t3 RESETn 502.463076507
CRESETn RESETn VSS 4.4258787e-14
RVDD_t0 VDD__t0 VDD 2.35999148776
RVDD_t1 VDD__t1 VDD 2.35999148776
RVDD_t2 VDD__t2 VDD 0.788098333131
RVDD_t3 VDD__t3 VDD 0.788098333131
RVDD_t4 VDD__t4 VDD 0.295249720716
RVDD_t5 VDD__t5 VDD 5.06439905244
RVDD_t6 VDD__t6 VDD 5.06439905244
RVDD_t7 VDD__t7 VDD 7.23527963295
RVDD_t8 VDD__t8 VDD 7.23527963295
RVDD_t9 VDD__t9 VDD 1.2760983336
RVDD_t10 VDD__t10 VDD 1.2760983336
RVDD_t11 VDD__t11 VDD 1.70838162397
RVDD_t12 VDD__t12 VDD 2.17294680535
RVDD_t13 VDD__t13 VDD 2.60734965526
RVDD_t14 VDD__t14 VDD 2.60734965526
RVDD_t15 VDD__t15 VDD 4.01357304527
RVDD_t16 VDD__t16 VDD 4.01357304527
RVDD_t17 VDD__t17 VDD 3.00712811554
RVDD_t18 VDD__t18 VDD 3.00712811554
RVDD_t19 VDD__t19 VDD 2.17294680535
RVDD_t20 VDD__t20 VDD 5.60920221824
RVDD_t21 VDD__t21 VDD 5.60920221824
RVDD_t22 VDD__t22 VDD 4.02007759857
RVDD_t23 VDD__t23 VDD 0.740540049554
RVDD_t24 VDD__t24 VDD 4.02007759857
RVDD_t25 VDD__t25 VDD 0.740540049554
CVDD VDD VSS 6.8863152e-14
RVSS_t0 VSS__t0 VSS 3.0504807567
RVSS_t1 VSS__t1 VSS 0.623413386554
RVSS_t2 VSS__t2 VSS 0.926502729824
RVSS_t3 VSS__t3 VSS 0.633889397759
RVSS_t4 VSS__t4 VSS 1.8412251982
RVSS_t5 VSS__t5 VSS 0.647622869458
RVSS_t6 VSS__t6 VSS 4.07178625969
RVSS_t7 VSS__t7 VSS 1.02751523267
RVSS_t8 VSS__t8 VSS 8.86000647857
RVSS_t9 VSS__t9 VSS 1.68526577635
RVSS_t10 VSS__t10 VSS 3.92540218501
RVSS_t11 VSS__t11 VSS 4.32044174866
RVSS_t12 VSS__t12 VSS 5.23235681228
RVSS_t13 VSS__t13 VSS 2.58794153849
RVSS_t14 VSS__t14 VSS 1.89460679736
RVSS_t15 VSS__t15 VSS 1.53287091387
RVSS_t16 VSS__t16 VSS 1.33211712448
RVSS_t17 VSS__t17 VSS 3.0504807567
RVSS_t18 VSS__t18 VSS 0.623413386554
RVSS_t19 VSS__t19 VSS 0.926502729824
RVSS_t20 VSS__t20 VSS 0.778793901586
RVSS_t21 VSS__t21 VSS 0.633889397759
RVSS_t22 VSS__t22 VSS 1.33211712448
RVSS_t23 VSS__t23 VSS 1.53287091387
RVSS_t24 VSS__t24 VSS 1.8412251982
RVSS_t25 VSS__t25 VSS 0.647622869458
RVSS_t26 VSS__t26 VSS 1.71372374734
RVSS_t27 VSS__t27 VSS 1.89460679736
RVSS_t28 VSS__t28 VSS 4.07178625969
RVSS_t29 VSS__t29 VSS 1.02751523267
RVSS_t30 VSS__t30 VSS 8.86000647857
CVSS VSS VSS 1.24338142e-13
Ccc__11__12 NDG PGDG 4.7222e-17
Ccc__11__13 NDG TIM 5.0173e-17
Ccc__11__14 NDG TRIP 4.7222e-17
Ccc__11__15 NDG NNAND 2.3611e-17
Ccc__11__17 NDG RSTB 7.0832e-17
Ccc__11__5 NDG PGDGB 4.7222e-17
Ccc__11__6 NDG ND1 4.7222e-17
Ccc__11__8 NDG NTS 2.3611e-17
Ccc__11_RESETn NDG RESETn 4.7222e-17
Ccc__11_VDD NDG VDD 1.5347e-16
Ccc__11_VSS NDG VSS 3.269281e-15
Ccc__13__14 TIM TRIP 4.7222e-17
Ccc__13__15 TIM NNAND 2.3611e-17
Ccc__13__17 TIM RSTB 7.0832e-17
Ccc__13__6 TIM ND1 4.7222e-17
Ccc__13_RESETn TIM RESETn 4.7222e-17
Ccc__13_VDD TIM VDD 1.5347e-16
Ccc__13_VSS TIM VSS 7.697882e-14
Rvsubs_dctie VSS 0 1e+12
.ends por_output_chain
