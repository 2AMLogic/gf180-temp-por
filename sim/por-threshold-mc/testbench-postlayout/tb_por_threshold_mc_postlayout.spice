* tb_por_threshold_mc_postlayout -- GENERATED by sim/build_tb.py
* Do not edit. Sources:
*   sim/por-threshold-mc/testbench/stimulus.spice
*   layout/postlayout/por_comparator.spice  (sha256 7f18f5adb295c1be56e6edfd1af6ad355c538bb78a4a2f56efe4aa786d864299)
* Regenerate with:
*   python3 sim/build_tb.py

* por-threshold-mc -- stimulus half of the testbench fragment.
*
* The other half is a verbatim copy of design/netlist/por_comparator.spice,
* appended by sim/build_tb.py to produce tb_por_threshold_mc.spice. Edit
* THIS file (or the schematic), never the generated fragment.
*
* Netlist FRAGMENT: no .include / .lib / .temp / .control / .end -- the
* harness owns those. Parameters supplied by sim/harness/montecarlo.py:
* vdd_val, vdd_nom, temp_c (plus .option seed=/.param sw_stat_mismatch=1).
*
* WHAT THIS EXPERIMENT SUBSTANTIATES (issue #15)
*
* spec/target-spec.md#por-vth-rise, #por-vth-fall, #por-hysteresis -- the
* LOCAL MISMATCH share (comparator input-pair offset, divider-ratio
* mismatch) of all three [3sigma] rows, at each row's own named binding
* corner (see the per-row "binds at" text in spec/target-spec.md section 4.1
* and sim/por-vth/'s measured record, which is where these five distinct
* (process, temperature, rail) binding points come from). Complements the
* deterministic corner-sweep systematic/corner share sim/por-vth/ (#14)
* already published on the full assembly.
*
* IDEALISED IBIAS/VREF, SAME CELL sim/por-comparator-designer-check/ uses --
* deliberate, not a cut corner, for the identical reason
* sim/temp-accuracy-mc/'s stimulus documents: the comparator's own offset and
* the divider's own ratio mismatch are properties of THIS cell's devices,
* not of bias_core's startup dynamics, so isolating them on the cheaper
* idealised-bias cell-level testbench is the right level to run N=500 per
* binding point x 5 binding points = 2500 ngspice invocations at. The
* assembled-path corner sweep (#14, sim/por-vth/) remains the authority for
* the process/temperature/rail axis; this experiment adds the local-mismatch
* axis on top, at #14's own measured binding points.
*
* ONE INSTANCE, ONE TRIANGLE WAVE -- load-bearing, not a simplification.
* sim/por-comparator-designer-check/ uses TWO instances (xup/xdn) for its
* rise/fall pair because with mismatch off (sw_stat_mismatch=0 there) the two
* instances are electrically identical, so "same corner point" is exact
* either way. Here mismatch is ON: two separate instances would draw TWO
* INDEPENDENT random mismatch realisations, so a "hysteresis" computed as
* their difference would be measuring cross-die spread dressed up as a
* same-die quantity -- exactly backwards from spec/target-spec.md's own
* framing ("Both edges measured at the same corner point (hysteresis is a
* same-die difference, not a corner-to-corner one)"). One instance, ramped
* up then down, guarantees both edges see the identical mismatch draw by
* construction.
*
* RAMP RATE: fast. Unlike sim/por-vth/'s full-assembly deck, IBIAS and VREF
* here are idealised DC sources with no startup/settling dynamics to wait
* out (matching sim/por-comparator-designer-check/'s own choice of a 10 ms
* single-edge ramp) -- there is no bias_core-starved-loop lag this comparator
* has to be given time to settle out of. 0 -> vdd_val in 5 ms, held to
* 10 ms, vdd_val -> 0 by 15 ms: comfortably inside the ratified
* por-ramp-rate envelope and enough for BIAS_OK-tied-high measurement of
* both crossings in one transient, at roughly 1 second of ngspice time per
* sample (see sim/harness montecarlo.py's module docstring for the budget
* this was sized against).
*
* BIAS_OK tied high throughout (including the 0 V endpoints), exactly as
* sim/por-comparator-designer-check/ does: this is the comparator's OWN
* threshold characteristic over its full input range, not a statement about
* when BIAS_OK is realistically valid (that ordering is #11/#14's job).

vsup vdd 0 pwl(0 0 5m {vdd_val} 10m {vdd_val} 15m 0)
vok bias_ok 0 dc {vdd_val}
vref vref 0 dc 1.2
ibref vdd ibias dc 500n
xdut vdd 0 ibias vref bias_ok por_raw por_comparator

* por_comparator -- post-layout netlist
* GENERATED by layout/postlayout.py -- do not edit.
*
* FROM THE LAYOUT: every device and its dimensions, the whole
*   topology, and first-order interconnect R/C on 15/15 nets
*   (sigma 526.8 fF, of which 0.057 fF is net-to-net coupling).
*   One star per net: <net> is the hub, <net>__t<k> each device
*   terminal on it, R<net>_t<k> the arm between them.
*   klt 0.6.0, deck gf180mcu,
*   GDS sha256 e6e5601250e6c78e...
* Net names are the schematic's, restored through klt lvs's own net
*   correspondence -- match, 15/15 nets, every one paired.
*
* NOT FROM THE LAYOUT -- see layout/postlayout/AUDIT.md:
*   3 body/plate net(s) tied to the net the schematic puts
*   them on. The extraction deck's connectivity stack does not reach
*   an Nwell, a substrate ring, a bipolar base well or a MiM plate,
*   so they extract isolated and would otherwise float.
*   No ideal device: every golden device is drawn.
*
.subckt por_comparator VDD VSS IBIAS VREF BIAS_OK POR_RAW

* --- drawn devices ---
X1 TN__t1 NBG__t0 VSS__t2 VSS__t13 nfet_03v3 L=10u W=1u nf=1 ad=0.8p as=0.8p pd=3.6u ps=3.6u m=1
X2 IBIAS__t2 BIAS_OKB__t2 VSS__t3 VSS__t14 nfet_03v3 L=1u W=1u nf=1 ad=0.8p as=0.8p pd=3.6u ps=3.6u m=1
X3 N1__t2 CMPO__t1 VSS__t5 VSS__t15 nfet_03v3 L=0.5u W=1u nf=1 ad=0.8p as=0.8p pd=3.6u ps=3.6u m=1
X4 POR_RAW__t0 N1__t3 VSS__t7 VSS__t16 nfet_03v3 L=0.5u W=1u nf=1 ad=0.8p as=0.8p pd=3.6u ps=3.6u m=1
X5 BIAS_OKB__t4 BIAS_OK__t0 VSS__t6 VSS__t17 nfet_03v3 L=0.5u W=1u nf=1 ad=0.8p as=0.5p pd=3.6u ps=3u m=1
X6 NA__t2 SNS__t2 TN__t0 VSS__t18 nfet_03v3 L=1u W=2u nf=1 ad=1.6p as=1.6p pd=5.6u ps=5.6u m=1
X7 CMPO__t2 VREF__t0 TN__t2 VSS__t19 nfet_03v3 L=1u W=2u nf=1 ad=1.6p as=1.6p pd=5.6u ps=5.6u m=1
X8 IBIAS__t0 NBG__t1 VSS__t1 VSS__t21 nfet_03v3 L=2u W=2u nf=1 ad=1.6p as=1.6p pd=5.6u ps=5.6u m=1
X9 IBIAS__t1 BIAS_OK__t2 NBG__t2 VSS__t22 nfet_03v3 L=0.5u W=2u nf=1 ad=1.6p as=1.6p pd=5.6u ps=5.6u m=1
X10 NBG__t3 BIAS_OKB__t1 VSS__t8 VSS__t23 nfet_03v3 L=0.5u W=2u nf=1 ad=1.6p as=1.6p pd=5.6u ps=5.6u m=1
X11 CMPO__t3 BIAS_OKB__t3 VSS__t9 VSS__t20 nfet_03v3 L=1u W=2u nf=1 ad=1.6p as=1.6p pd=5.6u ps=5.6u m=1
X12 SNSB__t1 N1__t1 VSS__t4 VSS__t24 nfet_03v3 L=0.5u W=10u nf=1 ad=8p as=8p pd=21.6u ps=21.6u m=1
X13 N1__t0 CMPO__t0 VDD__t3 VDD__t4 pfet_03v3 L=0.5u W=2u nf=1 ad=1.6p as=1.6p pd=5.6u ps=5.6u m=1
X14 POR_RAW__t1 N1__t4 VDD__t9 VDD__t8 pfet_03v3 L=0.5u W=2u nf=1 ad=1.6p as=1.6p pd=5.6u ps=5.6u m=1
X15 NA__t0 NA__t1 VDDA__t0 VDD__t0 pfet_03v3 L=1u W=4u nf=1 ad=3.2p as=3.2p pd=9.6u ps=9.6u m=1
X16 CMPO__t4 NA__t3 VDDA__t2 VDD__t10 pfet_03v3 L=1u W=4u nf=1 ad=3.2p as=3.2p pd=9.6u ps=9.6u m=1
X17 VDDA__t1 BIAS_OKB__t0 VDD__t1 VDD__t2 pfet_03v3 L=0.5u W=4u nf=1 ad=3.2p as=3.2p pd=9.6u ps=9.6u m=1
X18 BIAS_OKB__t5 BIAS_OK__t1 VDD__t5 VDD__t6 pfet_03v3 L=0.5u W=2u nf=1 ad=1.6p as=1p pd=5.6u ps=5u m=1
X19 SNSB__t0 SNS__t1 VSS__t10 ppolyf_u_3k r_width=2u r_length=6769.23u
X20 VSS__t0 SNSB__t2 VSS__t11 ppolyf_u_3k r_width=2u r_length=775u
X21 SNS__t0 VDD__t7 VSS__t12 ppolyf_u_3k r_width=2u r_length=7897.44u

R_10_t0 SNS__t0 SNS 122.891188735
R_10_t1 SNS__t1 SNS 684.260298411
R_10_t2 SNS__t2 SNS 686.317212854
C_10 SNS VSS 5.2676745e-14
R_12_t0 NBG__t0 NBG 715.139441326
R_12_t1 NBG__t1 NBG 44.0457601943
R_12_t2 NBG__t2 NBG 257.887617601
R_12_t3 NBG__t3 NBG 499.88258088
C_12 NBG VSS 2.1326008e-14
R_14_t0 SNSB__t0 SNSB 212.505970377
R_14_t1 SNSB__t1 SNSB 688.024299088
R_14_t2 SNSB__t2 SNSB 513.046030534
C_14 SNSB VSS 4.4264354e-14
R_3_t0 VDDA__t0 VDDA 631.9122
R_3_t1 VDDA__t1 VDDA 616.937977251
R_3_t2 VDDA__t2 VDDA 14.9742227488
C_3 VDDA VSS 1.4679011e-14
R_4_t0 NA__t0 NA 288.034386996
R_4_t1 NA__t1 NA 288.034386996
R_4_t2 NA__t2 NA 692.332138375
R_4_t3 NA__t3 NA 116.445087634
C_4 NA VSS 1.5868526e-14
R_5_t0 CMPO__t0 CMPO 261.418858782
R_5_t1 CMPO__t1 CMPO 366.105615344
R_5_t2 CMPO__t2 CMPO 88.9071013133
R_5_t3 CMPO__t3 CMPO 324.899769804
R_5_t4 CMPO__t4 CMPO 340.793554757
C_5 CMPO VSS 1.7766709e-14
R_7_t0 N1__t0 N1 377.193158999
R_7_t1 N1__t1 N1 175.868361694
R_7_t2 N1__t2 N1 253.833596266
R_7_t3 N1__t3 N1 292.041043747
R_7_t4 N1__t4 N1 338.946339293
C_7 N1 VSS 1.7866109e-14
R_9_t0 TN__t0 TN 486.762381087
R_9_t1 TN__t1 TN 630.394143252
R_9_t2 TN__t2 TN 143.96957566
C_9 TN VSS 1.3588667e-14
RBIAS_OK_t0 BIAS_OK__t0 BIAS_OK 363.218515086
RBIAS_OK_t1 BIAS_OK__t1 BIAS_OK 369.383580086
RBIAS_OK_t2 BIAS_OK__t2 BIAS_OK 719.565404828
CBIAS_OK BIAS_OK VSS 1.5010689e-14
RBIAS_OKB_t0 BIAS_OKB__t0 BIAS_OKB 744.308889961
RBIAS_OKB_t1 BIAS_OKB__t1 BIAS_OKB 59.9080526262
RBIAS_OKB_t2 BIAS_OKB__t2 BIAS_OKB 17.0676522536
RBIAS_OKB_t3 BIAS_OKB__t3 BIAS_OKB 109.722398109
RBIAS_OKB_t4 BIAS_OKB__t4 BIAS_OKB 349.031750011
RBIAS_OKB_t5 BIAS_OKB__t5 BIAS_OKB 351.14495704
CBIAS_OKB BIAS_OKB VSS 2.1654538e-14
RIBIAS_t0 IBIAS__t0 IBIAS 533.695252733
RIBIAS_t1 IBIAS__t1 IBIAS 99.7987141232
RIBIAS_t2 IBIAS__t2 IBIAS 632.489533144
CIBIAS IBIAS VSS 1.5551286e-14
RPOR_RAW_t0 POR_RAW__t0 POR_RAW 630.2627
RPOR_RAW_t1 POR_RAW__t1 POR_RAW 630.2627
CPOR_RAW POR_RAW VSS 1.3389027e-14
RVDD_t0 VDD__t0 VDD 5.9041895961
RVDD_t1 VDD__t1 VDD 4.71508973949
RVDD_t2 VDD__t2 VDD 4.71508973949
RVDD_t3 VDD__t3 VDD 4.24096746289
RVDD_t4 VDD__t4 VDD 4.24096746289
RVDD_t5 VDD__t5 VDD 6.87650413981
RVDD_t6 VDD__t6 VDD 6.87650413981
RVDD_t7 VDD__t7 VDD 24.3165014744
RVDD_t8 VDD__t8 VDD 3.72828176386
RVDD_t9 VDD__t9 VDD 3.72828176386
RVDD_t10 VDD__t10 VDD 5.28662271739
CVDD VDD VSS 5.2337816e-14
RVREF_t0 VREF__t0 VREF 1314.9134
CVREF VREF VSS 1.1576327e-14
RVSS_t0 VSS__t0 VSS 21.9623916049
RVSS_t1 VSS__t1 VSS 3.68926797329
RVSS_t2 VSS__t2 VSS 4.28730713656
RVSS_t3 VSS__t3 VSS 2.98646338292
RVSS_t4 VSS__t4 VSS 2.71447557922
RVSS_t5 VSS__t5 VSS 2.3015019586
RVSS_t6 VSS__t6 VSS 1.57310764032
RVSS_t7 VSS__t7 VSS 2.09215843778
RVSS_t8 VSS__t8 VSS 3.21060999989
RVSS_t9 VSS__t9 VSS 2.52186312651
RVSS_t10 VSS__t10 VSS 15.4918826332
RVSS_t11 VSS__t11 VSS 21.9623916049
RVSS_t12 VSS__t12 VSS 6.28602125058
RVSS_t13 VSS__t13 VSS 4.28730713656
RVSS_t14 VSS__t14 VSS 2.98646338292
RVSS_t15 VSS__t15 VSS 2.3015019586
RVSS_t16 VSS__t16 VSS 2.09215843778
RVSS_t17 VSS__t17 VSS 1.57310764032
RVSS_t18 VSS__t18 VSS 5.09283406728
RVSS_t19 VSS__t19 VSS 4.84353174536
RVSS_t20 VSS__t20 VSS 2.52186312651
RVSS_t21 VSS__t21 VSS 3.68926797329
RVSS_t22 VSS__t22 VSS 3.42393662359
RVSS_t23 VSS__t23 VSS 3.21060999989
RVSS_t24 VSS__t24 VSS 2.71447557922
CVSS VSS VSS 1.99238424e-13
Ccc__10__14 SNS SNSB 1.8889e-17
Ccc__10_BIAS_OK SNS BIAS_OK 9.444e-18
Ccc__10_BIAS_OKB SNS BIAS_OKB 9.444e-18
Ccc__10_VDD SNS VDD 9.444e-18
Ccc__14_VDD SNSB VDD 9.444e-18
Rvsubs_dctie VSS 0 1e+12
.ends por_comparator
