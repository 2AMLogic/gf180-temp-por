* tb_por_comparator_postlayout -- GENERATED by sim/build_tb.py
* Do not edit. Sources:
*   sim/por-comparator-designer-check/testbench/stimulus.spice
*   layout/postlayout/por_comparator.spice  (sha256 b6875e1abe48b7722efe59150dd9fefc0f2a0fb7c569851aedb1181217d1e404)
* Regenerate with:
*   python3 sim/build_tb.py

* por-comparator-designer-check -- stimulus half of the testbench fragment.
*
* The other half is a verbatim copy of design/netlist/por_comparator.spice,
* appended by sim/build_tb.py to produce tb_por_comparator.spice. Edit THIS
* file (or the schematic), never the generated fragment.
*
* Netlist FRAGMENT: no .include / .lib / .temp / .control / .end -- the
* harness owns those. Parameters it supplies: vdd_val, vdd_nom, temp_c, plus
* `dvdd_dt_v_per_s` from ../testbench/tb.json's `params` map (issue #206).
*
* RAMP RATE: dVDD/dt CONSTANT ACROSS THE SUPPLY AXIS (issue #206). Both ramp
* branches (1, 2 below) used to traverse 0 -> vdd_val (or the reverse) in a
* FIXED 10 ms, so dVDD/dt was itself a function of vdd_val -- 297 / 330 /
* 363 V/s at 2.97 / 3.30 / 3.63 V -- the same shape of confound
* sim/por-vth/'s stimulus had, with a smaller coefficient because VREF here
* is an idealised fixed 1.2 V source (zero output impedance, so it cannot be
* displaced by the moving rail the way bias_core's real reference is -- see
* sim/por-vth/control/results.md). The duration is now DERIVED from a
* constant `dvdd_dt_v_per_s` (../testbench/tb.json's `params`):
* `tramp = vdd_val / dvdd_dt_v_per_s`. The chosen rate, 297 V/s, is not a new
* number -- it is this deck's own 2.97 V corner's native rate under the old
* fixed-10-ms scheme, so that corner's reading is bit-for-bit unchanged by
* this fix, matching the reuse-the-slowest-native-rate choice
* sim/por-vth/testbench/stimulus.spice makes for the same reason.
*
* bias_core (issue #11) is still a placeholder, so IBIAS and VREF are
* idealised fixed stimuli here, exactly like temp-core-designer-check does
* for IBIAS: 500 nA into IBIAS, 1.2 V (bandgap-scale, per
* sim/devchar/SUMMARY.md's "comparator input pair" note) into VREF. This is
* the comparator's OWN intrinsic threshold characteristic, independent of
* #11's real startup-ordering timing -- the more realistic ramped-together
* bring-up (BIAS_OK arriving after VREF settles, per DR-005 startup step 4)
* is #14's job, matching temp-core-startup's precedent for the analogous
* split.
*
* Five independent branches:
*
*   1/2. xup / xdn  a VDD 0->vdd_val ramp and a vdd_val->0 ramp, run in the
*        SAME transient so both edges of one hysteresis pair are measured
*        at the same corner point (spec/target-spec.md#por-hysteresis).
*        BIAS_OK is tied high throughout each ramp (including down to 0 V)
*        so the sweep captures the comparator's own threshold characteristic
*        over the full range, including below its own operating floor --
*        see the Test Plan's edge-case bullet. VREF/IBIAS ride the block's
*        own separately-referenced idealised sources.
*   3. xiq   a static enabled DUT at this point's vdd_val, for the settled
*        (released) Iq reading, IBIAS sourced from the measured rail so the
*        reading is DR-007 rule 1's conservative number.
*   4. xiqdis  a static DUT at this point's vdd_val with BIAS_OK held low
*        throughout, for the pre-bias-core-valid Iq reading. This is also the
*        divider's worst-case (RHYS shorted) configuration at full rail.
*   5. xiqown  the same enabled DUT as branch 3 but with IBIAS sourced from a
*        SEPARATE rail, so vsupown measures the cell's OWN draw with the
*        shared reference current excluded. iq_run_ua - iq_own_ua is the
*        reference current by construction, which is what #11 needs to see.
*
* The rising and falling ramps use two DUT instances rather than one ramp with
* a fold-back, so each edge is measured on a monotonic sweep with a settled
* history. sw_stat_mismatch=0 in design.ngspice, so the two instances are
* electrically identical and "same corner point" is exact, not approximate --
* mismatch between them is #15's Monte Carlo job.
*
* Absolute-temperature probe not needed here (no temperature-dependent
* transfer function is being extracted, only threshold voltages and Iq).

.param tramp='vdd_val/dvdd_dt_v_per_s'

* ---- 1. rising ramp: VPOR-uparrow -------------------------------------
vsupup vddup 0 pwl(0 0 {tramp} {vdd_val})
vokup bias_okup 0 dc {vdd_val}
vrefup vrefup 0 dc 1.2
ibrefup vddup ibiasup dc 500n
xup vddup 0 ibiasup vrefup bias_okup por_rawup por_comparator

* ---- 1b. rising ramp with VREF deliberately 5 % high --------------------
* Identical to branch 1 except VREF = 1.26 V instead of 1.20 V. The whole
* threshold is VREF times a resistor ratio, so this branch MEASURES the
* fractional sensitivity d(VPOR)/VPOR per d(VREF)/VREF instead of leaving it
* as algebra -- which is the number bias_core (#11) has to design its
* reference accuracy against, since this cell spends almost none of the
* ratified +/-5 % window itself.
vsupur vddur 0 pwl(0 0 {tramp} {vdd_val})
vokur bias_okur 0 dc {vdd_val}
vrefur vrefur 0 dc 1.26
ibrefur vddur ibiasur dc 500n
xupr vddur 0 ibiasur vrefur bias_okur por_rawur por_comparator

* ---- 2. falling ramp: VPOR-downarrow, same corner point ----------------
vsupdn vdddn 0 pwl(0 {vdd_val} {tramp} 0)
vokdn bias_okdn 0 dc {vdd_val}
vrefdn vrefdn 0 dc 1.2
ibrefdn vdddn ibiasdn dc 500n
xdn vdddn 0 ibiasdn vrefdn bias_okdn por_rawdn por_comparator

* ---- 3. enabled DUT, settled at this point's vdd_val --------------------
vsupiq vddiq 0 dc {vdd_val}
vokiq bias_okiq 0 dc {vdd_val}
vrefiq vrefiq 0 dc 1.2
ibrefiq vddiq ibiasiq dc 500n
xiq vddiq 0 ibiasiq vrefiq bias_okiq por_rawiq por_comparator

* ---- 4. disabled DUT (BIAS_OK low), settled at this point's vdd_val -----
vsupdis vdddis 0 dc {vdd_val}
vokdis bias_okdis 0 dc 0
vrefdis vrefdis 0 dc 1.2
ibrefdis vdddis ibiasdis dc 500n
xiqdis vdddis 0 ibiasdis vrefdis bias_okdis por_rawdis por_comparator

* ---- 5. enabled DUT, IBIAS referenced to its OWN separate rail -----------
* Same operating point as branch 3; the only difference is that the 500 nA
* reference is pushed in from vbrown, not from the rail vsupown measures. So
* iq_own_ua is por_comparator's own consumption and iq_run_ua - iq_own_ua is
* exactly the reference current, with no arithmetic across PVT points.
vsupown vddown 0 dc {vdd_val}
vokown bias_okown 0 dc {vdd_val}
vrefown vrefown 0 dc 1.2
vbown vbrown 0 dc {vdd_val}
ibrefown vbrown ibiasown dc 500n
xiqown vddown 0 ibiasown vrefown bias_okown por_rawown por_comparator

* por_comparator -- post-layout netlist
* GENERATED by layout/postlayout.py -- do not edit.
*
* FROM THE LAYOUT: every device and its dimensions, the whole
*   topology, and first-order interconnect R/C on 15/18 nets
*   (sigma 473.0 fF). klt 0.2.0, deck gf180mcu,
*   GDS sha256 45b4b14914c4e651...
* Net names are the schematic's, restored through klt lvs's own net
*   correspondence -- match, 18/18 nets, every one paired.
*
* NOT FROM THE LAYOUT -- see layout/postlayout/AUDIT.md:
*   3 body/plate net(s) tied to the net the schematic puts
*   them on. The extraction deck's connectivity stack does not reach
*   an Nwell, a substrate ring, a bipolar base well or a MiM plate,
*   so they extract isolated and would otherwise float.
*   No ideal device: every golden device is drawn.
*
.subckt por_comparator VDD VSS IBIAS VREF BIAS_OK POR_RAW

* --- drawn devices ---
X1 TN NBG VSS VSS nfet_03v3 L=10u W=1u nf=1 ad=0.8p as=0.8p pd=3.6u ps=3.6u m=1
X2 IBIAS BIAS_OKB VSS VSS nfet_03v3 L=1u W=1u nf=1 ad=0.8p as=0.8p pd=3.6u ps=3.6u m=1
X3 N1 CMPO VSS VSS nfet_03v3 L=0.5u W=1u nf=1 ad=0.8p as=0.8p pd=3.6u ps=3.6u m=1
X4 POR_RAW N1 VSS VSS nfet_03v3 L=0.5u W=1u nf=1 ad=0.8p as=0.8p pd=3.6u ps=3.6u m=1
X5 BIAS_OKB BIAS_OK VSS VSS nfet_03v3 L=0.5u W=1u nf=1 ad=0.8p as=0.5p pd=3.6u ps=3u m=1
X6 NA SNS TN VSS nfet_03v3 L=1u W=2u nf=1 ad=1.6p as=1.6p pd=5.6u ps=5.6u m=1
X7 CMPO VREF TN VSS nfet_03v3 L=1u W=2u nf=1 ad=1.6p as=1.6p pd=5.6u ps=5.6u m=1
X8 IBIAS NBG VSS VSS nfet_03v3 L=2u W=2u nf=1 ad=1.6p as=1.6p pd=5.6u ps=5.6u m=1
X9 IBIAS BIAS_OK NBG VSS nfet_03v3 L=0.5u W=2u nf=1 ad=1.6p as=1.6p pd=5.6u ps=5.6u m=1
X10 NBG BIAS_OKB VSS VSS nfet_03v3 L=0.5u W=2u nf=1 ad=1.6p as=1.6p pd=5.6u ps=5.6u m=1
X11 CMPO BIAS_OKB VSS VSS nfet_03v3 L=1u W=2u nf=1 ad=1.6p as=1.6p pd=5.6u ps=5.6u m=1
X12 SNSB N1 VSS VSS nfet_03v3 L=0.5u W=10u nf=1 ad=8p as=8p pd=21.6u ps=21.6u m=1
X13 N1 CMPO VDD VDD pfet_03v3 L=0.5u W=2u nf=1 ad=1.6p as=1.6p pd=5.6u ps=5.6u m=1
X14 POR_RAW N1 VDD VDD pfet_03v3 L=0.5u W=2u nf=1 ad=1.6p as=1.6p pd=5.6u ps=5.6u m=1
X15 NA NA VDDA VDD pfet_03v3 L=1u W=4u nf=1 ad=3.2p as=3.2p pd=9.6u ps=9.6u m=1
X16 CMPO NA VDDA VDD pfet_03v3 L=1u W=4u nf=1 ad=3.2p as=3.2p pd=9.6u ps=9.6u m=1
X17 VDDA BIAS_OKB VDD VDD pfet_03v3 L=0.5u W=4u nf=1 ad=3.2p as=3.2p pd=9.6u ps=9.6u m=1
X18 BIAS_OKB BIAS_OK VDD VDD pfet_03v3 L=0.5u W=2u nf=1 ad=1.6p as=1p pd=5.6u ps=5u m=1
X19 SNS VDD VSS ppolyf_u_3k r_width=2u r_length=7897.44u
X20 SNSB SNS VSS ppolyf_u_3k r_width=2u r_length=6769.23u
X21 VSS SNSB VSS ppolyf_u_3k r_width=2u r_length=775u

R_10 SNS SNS__par 1410.6865
C_10 SNS__par VSS 2.5945833e-14
R_12 NBG NBG__par 1516.9554
C_12 NBG__par VSS 2.1326008e-14
R_14 SNSB SNSB__par 1330.8009
C_14 SNSB__par VSS 1.7531363e-14
R_3 VDDA VDDA__par 1263.8244
C_3 VDDA__par VSS 1.4679011e-14
R_4 NA NA__par 1384.846
C_4 NA__par VSS 1.5868526e-14
R_5 CMPO CMPO__par 1382.1249
C_5 CMPO__par VSS 1.7766709e-14
R_7 N1 N1__par 1437.8825
C_7 N1__par VSS 1.7866109e-14
R_9 TN TN__par 1261.1261
C_9 TN__par VSS 1.3588667e-14
RBIAS_OK BIAS_OK BIAS_OK__par 1452.1675
CBIAS_OK BIAS_OK__par VSS 1.5015489e-14
RBIAS_OKB BIAS_OKB BIAS_OKB__par 1631.1837
CBIAS_OKB BIAS_OKB__par VSS 2.1659338e-14
RIBIAS IBIAS IBIAS__par 1265.9835
CIBIAS IBIAS__par VSS 1.5551286e-14
RPOR_RAW POR_RAW POR_RAW__par 1260.5254
CPOR_RAW POR_RAW__par VSS 1.3389027e-14
RVDD VDD VDD__par 74.7605
CVDD VDD__par VSS 5.225586e-14
RVREF VREF VREF__par 1314.9134
CVREF VREF__par VSS 1.1576327e-14
RVSS VSS VSS__par 129.7465
CVSS VSS__par VSS 1.989616e-13
.ends por_comparator
