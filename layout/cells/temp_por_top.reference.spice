* temp_por_top -- klt lvs reference netlist
* generated by layout/lvs_reference.py from design/netlist/temp_por_top.spice
* Do not edit: edit the schematic, re-run design/netlist.py, re-run this.
.SUBCKT temp_por_top VDD VSS PTAT CTAT RESETn vsubs
M1 xbias.NBG xbias.NBG VSS vsubs nfet L=4U W=2U
M2 xbias.NA xbias.PG VDD xbias.NW1 pfet L=4U W=8U
M3 xbias.NBTOP xbias.PG VDD xbias.NW1 pfet L=4U W=8U
M4 VREF xbias.PG VDD xbias.NW1 pfet L=4U W=8U
M5 xbias.NBG xbias.PG VDD xbias.NW1 pfet L=4U W=2U
M6 xbias.PB xbias.PB VDD xbias.NW1 pfet L=4U W=2U
M7 IBIAS xbias.PB VDD xbias.NW1 pfet L=4U W=40U
M8 xbias.NT xbias.PB VDD xbias.NW1 pfet L=4U W=2U
M9 xbias.N1 xbias.NA xbias.NT xbias.NW1 pfet L=4U W=16U
M10 xbias.N2 xbias.NB xbias.NT xbias.NW1 pfet L=4U W=16U
M11 xbias.PG xbias.PB VDD xbias.NW1 pfet L=4U W=2U
M12 xbias.NKM xbias.PB VDD xbias.NW1 pfet L=4U W=1U
M13 xbias.TOK xbias.PB VDD xbias.NW1 pfet L=4U W=1U
M14 xbias.NOKO xbias.NA xbias.TOK xbias.NW1 pfet L=4U W=8U
M15 xbias.NOKL xbias.NBTOP xbias.TOK xbias.NW1 pfet L=4U W=8U
M16 xbias.NOKX xbias.PB VDD xbias.NW1 pfet L=4U W=1U
M17 BIAS_OK xbias.NOKX VDD xbias.NW1 pfet L=4U W=1U
M18 xbias.PB xbias.NBG VSS vsubs nfet L=4U W=2U
M19 xbias.N1 xbias.N1 VSS vsubs nfet L=8U W=4U
M20 xbias.N2 xbias.N1 VSS vsubs nfet L=8U W=4U
M21 xbias.PG xbias.N2 VSS vsubs nfet L=8U W=8U
M22 VDD VDD xbias.KS1 vsubs nfet L=8U W=1U
M23 xbias.KS1 xbias.KS1 xbias.KS2 vsubs nfet L=8U W=1U
M24 xbias.KS2 xbias.KS2 xbias.KS3 vsubs nfet L=8U W=1U
M25 xbias.KS3 xbias.KS3 xbias.KS4 vsubs nfet L=8U W=1U
M26 xbias.KS4 xbias.KS4 xbias.NKG vsubs nfet L=8U W=1U
M27 xbias.NKM xbias.NKM VSS vsubs nfet L=4U W=2U
M28 xbias.NKG xbias.NKM VSS vsubs nfet L=4U W=8U
M29 xbias.PG xbias.NKG VSS vsubs nfet L=4U W=1U
M30 xbias.NOKL xbias.NOKL VSS vsubs nfet L=4U W=2U
M31 xbias.NOKO xbias.NOKL VSS vsubs nfet L=4U W=2U
M32 xbias.NOKO xbias.NKG VSS vsubs nfet L=1U W=2U
M33 xbias.NOKX xbias.NOKO VSS vsubs nfet L=4U W=2U
M34 BIAS_OK xbias.NOKX VSS vsubs nfet L=0.5U W=4U
M35 xcmp.BIAS_OKB BIAS_OK VSS vsubs nfet L=0.5U W=1U
M36 xcmp.BIAS_OKB BIAS_OK VDD xcmp.NW2 pfet L=0.5U W=2U
M37 xcmp.NA xcmp.NA xcmp.VDDA xcmp.NW1 pfet L=1U W=4U
M38 xcmp.CMPO xcmp.NA xcmp.VDDA xcmp.NW1 pfet L=1U W=4U
M39 xcmp.VDDA xcmp.BIAS_OKB VDD xcmp.NW1 pfet L=0.5U W=4U
M40 xcmp.N1 xcmp.CMPO VDD xcmp.NW1 pfet L=0.5U W=2U
M41 POR_RAW xcmp.N1 VDD xcmp.NW1 pfet L=0.5U W=2U
M42 xcmp.NA xcmp.SNS xcmp.TN vsubs nfet L=1U W=2U
M43 xcmp.CMPO VREF xcmp.TN vsubs nfet L=1U W=2U
M44 xcmp.TN xcmp.NBG VSS vsubs nfet L=10U W=1U
M45 IBIAS xcmp.NBG VSS vsubs nfet L=2U W=2U
M46 IBIAS BIAS_OK xcmp.NBG vsubs nfet L=0.5U W=2U
M47 xcmp.NBG xcmp.BIAS_OKB VSS vsubs nfet L=0.5U W=2U
M48 IBIAS xcmp.BIAS_OKB VSS vsubs nfet L=1U W=1U
M49 xcmp.SNSB xcmp.N1 VSS vsubs nfet L=0.5U W=10U
M50 xcmp.CMPO xcmp.BIAS_OKB VSS vsubs nfet L=1U W=2U
M51 xcmp.N1 xcmp.CMPO VSS vsubs nfet L=0.5U W=1U
M52 POR_RAW xcmp.N1 VSS vsubs nfet L=0.5U W=1U
M53 IBIAS IBIAS VSS vsubs nfet L=4U W=4U
M54 xpor.PDN xpor.PDN VDD xpor.NW1 pfet L=10U W=2U
M55 xpor.PDN IBIAS VSS vsubs nfet L=25U W=0.5U
M56 xpor.NDL xpor.NDL VSS vsubs nfet L=10U W=2U
M57 xpor.NDGN xpor.NDL VSS vsubs nfet L=10U W=10U
M58 xpor.NDG POR_RAW xpor.NDGN vsubs nfet L=0.5U W=1U
M59 xpor.PGDG xpor.NDG VSS vsubs nfet L=0.5U W=2U
M60 xpor.PGDGB xpor.PGDG VSS vsubs nfet L=2U W=0.5U
M61 xpor.TIM xpor.PGDGB VSS vsubs nfet L=1U W=1U
M62 xpor.ND1 xpor.NDL VSS vsubs nfet L=10U W=0.5U
M63 xpor.TRIP xpor.ND1 VSS vsubs nfet L=1U W=1U
M64 xpor.RSTB xpor.TRIP xpor.NNAND vsubs nfet L=0.5U W=2U
M65 xpor.NNAND xpor.PGDG VSS vsubs nfet L=0.5U W=2U
M66 RESETn xpor.RSTB VSS vsubs nfet L=0.5U W=10U
M67 xpor.NDL xpor.PDN VDD xpor.NW1 pfet L=10U W=2U
M68 xpor.NDGP xpor.PDN VDD xpor.NW1 pfet L=10U W=10U
M69 xpor.NTS xpor.PDN VDD xpor.NW1 pfet L=10U W=0.5U
M70 xpor.TRIP xpor.PDN VDD xpor.NW1 pfet L=10U W=0.5U
M71 xpor.NDG POR_RAW xpor.NDGP xpor.NW1 pfet L=0.5U W=1U
M72 xpor.PGDG xpor.NDG VDD xpor.NW1 pfet L=2U W=0.5U
M73 xpor.PGDGB xpor.PGDG VDD xpor.NW1 pfet L=0.5U W=2U
M74 xpor.TIM xpor.PGDGB xpor.NTS xpor.NW1 pfet L=1U W=2U
M75 xpor.ND1 xpor.TIM VDD xpor.NW1 pfet L=1U W=2U
M76 xpor.RSTB xpor.TRIP VDD xpor.NW1 pfet L=0.5U W=4U
M77 xpor.RSTB xpor.PGDG VDD xpor.NW1 pfet L=0.5U W=4U
M78 xpor.RSTB RESETn VDD xpor.NW1 pfet L=10U W=0.5U
M79 RESETn xpor.RSTB VDD xpor.NW1 pfet L=1U W=1U
M80 IBIAS xtemp.NBG VSS vsubs nfet L=2U W=4U
M81 IBIAS RESETn xtemp.NBG vsubs nfet L=0.5U W=2U
M82 xtemp.NBG xtemp.ENB VSS vsubs nfet L=0.5U W=2U
M83 xtemp.PB xtemp.NBG VSS vsubs nfet L=2U W=4U
M84 xtemp.PB xtemp.PB VDD xtemp.NW1 pfet L=4U W=10U
M85 xtemp.PCAS xtemp.NBG VSS vsubs nfet L=2U W=4U
M86 xtemp.PCAS xtemp.PCAS VDD xtemp.NW1 pfet L=8U W=1U
M87 xtemp.ENB RESETn VDD xtemp.NW1 pfet L=0.5U W=2U
M88 xtemp.ENB RESETn VSS vsubs nfet L=0.5U W=1U
M89 xtemp.NT xtemp.PB VDD xtemp.NW1 pfet L=4U W=20U
M90 xtemp.N1 xtemp.NA xtemp.NT xtemp.NW2 pfet L=4U W=16U
M91 xtemp.N1 xtemp.NA xtemp.NT xtemp.NW2 pfet L=4U W=16U
M92 xtemp.N2 xtemp.NB xtemp.NT xtemp.NW2 pfet L=4U W=16U
M93 xtemp.N2 xtemp.NB xtemp.NT xtemp.NW2 pfet L=4U W=16U
M94 xtemp.N1 xtemp.N1 VSS vsubs nfet L=8U W=4U
M95 xtemp.N1 xtemp.N1 VSS vsubs nfet L=8U W=4U
M96 xtemp.N2 xtemp.N1 VSS vsubs nfet L=8U W=4U
M97 xtemp.N2 xtemp.N1 VSS vsubs nfet L=8U W=4U
M98 xtemp.PG xtemp.N2 VSS vsubs nfet L=8U W=8U
M99 xtemp.PG xtemp.PB VDD xtemp.NW1 pfet L=4U W=10U
M100 xtemp.M1D xtemp.PG VDD xtemp.NW1 pfet L=4U W=4U
M101 xtemp.M1D xtemp.PG VDD xtemp.NW1 pfet L=4U W=4U
M102 xtemp.NA xtemp.PCAS xtemp.M1D xtemp.NW1 pfet L=1U W=4U
M103 xtemp.NA xtemp.PCAS xtemp.M1D xtemp.NW1 pfet L=1U W=4U
M104 xtemp.M2D xtemp.PG VDD xtemp.NW1 pfet L=4U W=4U
M105 xtemp.M2D xtemp.PG VDD xtemp.NW1 pfet L=4U W=4U
M106 xtemp.NB xtemp.PCAS xtemp.M2D xtemp.NW1 pfet L=1U W=4U
M107 xtemp.NB xtemp.PCAS xtemp.M2D xtemp.NW1 pfet L=1U W=4U
M108 xtemp.M3D xtemp.PG VDD xtemp.NW1 pfet L=4U W=4U
M109 xtemp.M3D xtemp.PG VDD xtemp.NW1 pfet L=4U W=4U
M110 PTAT xtemp.PCAS xtemp.M3D xtemp.NW1 pfet L=1U W=4U
M111 PTAT xtemp.PCAS xtemp.M3D xtemp.NW1 pfet L=1U W=4U
M112 xtemp.ND xtemp.PB VDD xtemp.NW1 pfet L=8U W=1U
M113 xtemp.ND xtemp.NR VSS vsubs nfet L=2U W=2U
M114 xtemp.PG xtemp.ND VSS vsubs nfet L=1U W=4U
M115 xtemp.ND xtemp.ENB VSS vsubs nfet L=0.5U W=2U
M116 xtemp.PG RESETn VDD xtemp.NW1 pfet L=0.5U W=4U
M117 PTAT xtemp.ENB VSS vsubs nfet L=1U W=1U
M118 CTAT xtemp.ENB VSS vsubs nfet L=1U W=1U
M119 xtemp.NR xtemp.PG VDD xtemp.NW1 pfet L=4U W=1U
M120 xtemp.NR xtemp.NR VSS vsubs nfet L=2U W=2U
M121 xtemp.N2 xtemp.ENB VSS vsubs nfet L=1U W=2U
M122 xtemp.NT xtemp.ENB VSS vsubs nfet L=1U W=2U
M123 xtemp.T5 VDD xtemp.T4 vsubs nfet L=0.5U W=32U
M124 xtemp.T4 VSS xtemp.T3 vsubs nfet L=0.5U W=32U
M125 xtemp.T3 VSS xtemp.T2 vsubs nfet L=0.5U W=32U
M126 xtemp.T2 VSS xtemp.T1 vsubs nfet L=0.5U W=32U
M127 xtemp.T1 VSS xtemp.T0 vsubs nfet L=0.5U W=32U
M128 xtemp.T0 VSS VSS vsubs nfet L=0.5U W=32U
MD129 xtemp.NT xtemp.NT xtemp.NT xtemp.NW2 pfet L=4U W=16U
MD130 xtemp.NT xtemp.NT xtemp.NT xtemp.NW2 pfet L=4U W=16U
MD131 VSS VSS VSS vsubs nfet L=8U W=4U
MD132 VSS VSS VSS vsubs nfet L=8U W=4U
MD133 VDD VDD VDD xtemp.NW1 pfet L=4U W=4U
MD134 VDD VDD VDD xtemp.NW1 pfet L=4U W=4U
C1 xpor.XCDG.NDG xpor.XCDG.VSS 2.42e-13 cap_mim_2f0_m4m5_noshield
C2 xpor.XCTIM.1.TIM xpor.XCTIM.1.VSS 1.568e-12 cap_mim_2f0_m4m5_noshield
C3 xpor.XCTIM.2.TIM xpor.XCTIM.2.VSS 1.568e-12 cap_mim_2f0_m4m5_noshield
C4 xpor.XCTIM.3.TIM xpor.XCTIM.3.VSS 1.568e-12 cap_mim_2f0_m4m5_noshield
C5 xpor.XCTIM.4.TIM xpor.XCTIM.4.VSS 1.568e-12 cap_mim_2f0_m4m5_noshield
.ENDS temp_por_top
