* por-comparator-designer-check -- stimulus half of the testbench fragment.
*
* The other half is a verbatim copy of design/netlist/por_comparator.spice,
* appended by sim/build_tb.py to produce tb_por_comparator.spice. Edit THIS
* file (or the schematic), never the generated fragment.
*
* Netlist FRAGMENT: no .include / .lib / .temp / .control / .end -- the
* harness owns those. Parameters it supplies: vdd_val, vdd_nom, temp_c, plus
* `dvdd_dt_v_per_s` from ../testbench/tb.json's `params` map (issue #206).
*
* RAMP RATE: dVDD/dt CONSTANT ACROSS THE SUPPLY AXIS (issue #206). Both ramp
* branches (1, 2 below) used to traverse 0 -> vdd_val (or the reverse) in a
* FIXED 10 ms, so dVDD/dt was itself a function of vdd_val -- 297 / 330 /
* 363 V/s at 2.97 / 3.30 / 3.63 V -- the same shape of confound
* sim/por-vth/'s stimulus had, with a smaller coefficient because VREF here
* is an idealised fixed 1.2 V source (zero output impedance, so it cannot be
* displaced by the moving rail the way bias_core's real reference is -- see
* sim/por-vth/control/results.md). The duration is now DERIVED from a
* constant `dvdd_dt_v_per_s` (../testbench/tb.json's `params`):
* `tramp = vdd_val / dvdd_dt_v_per_s`. The chosen rate, 297 V/s, is not a new
* number -- it is this deck's own 2.97 V corner's native rate under the old
* fixed-10-ms scheme, so that corner's reading is bit-for-bit unchanged by
* this fix, matching the reuse-the-slowest-native-rate choice
* sim/por-vth/testbench/stimulus.spice makes for the same reason.
*
* bias_core (issue #11) is still a placeholder, so IBIAS and VREF are
* idealised fixed stimuli here, exactly like temp-core-designer-check does
* for IBIAS: 500 nA into IBIAS, 1.2 V (bandgap-scale, per
* sim/devchar/SUMMARY.md's "comparator input pair" note) into VREF. This is
* the comparator's OWN intrinsic threshold characteristic, independent of
* #11's real startup-ordering timing -- the more realistic ramped-together
* bring-up (BIAS_OK arriving after VREF settles, per DR-005 startup step 4)
* is #14's job, matching temp-core-startup's precedent for the analogous
* split.
*
* Five independent branches:
*
*   1/2. xup / xdn  a VDD 0->vdd_val ramp and a vdd_val->0 ramp, run in the
*        SAME transient so both edges of one hysteresis pair are measured
*        at the same corner point (spec/target-spec.md#por-hysteresis).
*        BIAS_OK is tied high throughout each ramp (including down to 0 V)
*        so the sweep captures the comparator's own threshold characteristic
*        over the full range, including below its own operating floor --
*        see the Test Plan's edge-case bullet. VREF/IBIAS ride the block's
*        own separately-referenced idealised sources.
*   3. xiq   a static enabled DUT at this point's vdd_val, for the settled
*        (released) Iq reading, IBIAS sourced from the measured rail so the
*        reading is DR-007 rule 1's conservative number.
*   4. xiqdis  a static DUT at this point's vdd_val with BIAS_OK held low
*        throughout, for the pre-bias-core-valid Iq reading. This is also the
*        divider's worst-case (RHYS shorted) configuration at full rail.
*   5. xiqown  the same enabled DUT as branch 3 but with IBIAS sourced from a
*        SEPARATE rail, so vsupown measures the cell's OWN draw with the
*        shared reference current excluded. iq_run_ua - iq_own_ua is the
*        reference current by construction, which is what #11 needs to see.
*
* The rising and falling ramps use two DUT instances rather than one ramp with
* a fold-back, so each edge is measured on a monotonic sweep with a settled
* history. sw_stat_mismatch=0 in design.ngspice, so the two instances are
* electrically identical and "same corner point" is exact, not approximate --
* mismatch between them is #15's Monte Carlo job.
*
* Absolute-temperature probe not needed here (no temperature-dependent
* transfer function is being extracted, only threshold voltages and Iq).

.param tramp='vdd_val/dvdd_dt_v_per_s'

* ---- 1. rising ramp: VPOR-uparrow -------------------------------------
vsupup vddup 0 pwl(0 0 {tramp} {vdd_val})
vokup bias_okup 0 dc {vdd_val}
vrefup vrefup 0 dc 1.2
ibrefup vddup ibiasup dc 500n
xup vddup 0 ibiasup vrefup bias_okup por_rawup por_comparator

* ---- 1b. rising ramp with VREF deliberately 5 % high --------------------
* Identical to branch 1 except VREF = 1.26 V instead of 1.20 V. The whole
* threshold is VREF times a resistor ratio, so this branch MEASURES the
* fractional sensitivity d(VPOR)/VPOR per d(VREF)/VREF instead of leaving it
* as algebra -- which is the number bias_core (#11) has to design its
* reference accuracy against, since this cell spends almost none of the
* ratified +/-5 % window itself.
vsupur vddur 0 pwl(0 0 {tramp} {vdd_val})
vokur bias_okur 0 dc {vdd_val}
vrefur vrefur 0 dc 1.26
ibrefur vddur ibiasur dc 500n
xupr vddur 0 ibiasur vrefur bias_okur por_rawur por_comparator

* ---- 2. falling ramp: VPOR-downarrow, same corner point ----------------
vsupdn vdddn 0 pwl(0 {vdd_val} {tramp} 0)
vokdn bias_okdn 0 dc {vdd_val}
vrefdn vrefdn 0 dc 1.2
ibrefdn vdddn ibiasdn dc 500n
xdn vdddn 0 ibiasdn vrefdn bias_okdn por_rawdn por_comparator

* ---- 3. enabled DUT, settled at this point's vdd_val --------------------
vsupiq vddiq 0 dc {vdd_val}
vokiq bias_okiq 0 dc {vdd_val}
vrefiq vrefiq 0 dc 1.2
ibrefiq vddiq ibiasiq dc 500n
xiq vddiq 0 ibiasiq vrefiq bias_okiq por_rawiq por_comparator

* ---- 4. disabled DUT (BIAS_OK low), settled at this point's vdd_val -----
vsupdis vdddis 0 dc {vdd_val}
vokdis bias_okdis 0 dc 0
vrefdis vrefdis 0 dc 1.2
ibrefdis vdddis ibiasdis dc 500n
xiqdis vdddis 0 ibiasdis vrefdis bias_okdis por_rawdis por_comparator

* ---- 5. enabled DUT, IBIAS referenced to its OWN separate rail -----------
* Same operating point as branch 3; the only difference is that the 500 nA
* reference is pushed in from vbrown, not from the rail vsupown measures. So
* iq_own_ua is por_comparator's own consumption and iq_run_ua - iq_own_ua is
* exactly the reference current, with no arithmetic across PVT points.
vsupown vddown 0 dc {vdd_val}
vokown bias_okown 0 dc {vdd_val}
vrefown vrefown 0 dc 1.2
vbown vbrown 0 dc {vdd_val}
ibrefown vbrown ibiasown dc 500n
xiqown vddown 0 ibiasown vrefown bias_okown por_rawown por_comparator
