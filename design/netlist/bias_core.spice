* bias_core -- generated by design/netlist.py from design/bias_core.sch
* Do not edit: edit the schematic and re-run the export.
** sch_path: design/bias_core.sch
.subckt bias_core VDD VSS IBIAS VREF BIAS_OK
*.PININFO VDD:B VSS:B IBIAS:O VREF:O BIAS_OK:O
Rplaceholder_ibias IBIAS VSS 1T m=1
Rplaceholder_vref VREF VSS 1T m=1
Rplaceholder_bias_ok BIAS_OK VSS 1T m=1
**** begin user architecture code

* PLACEHOLDER: bias_core has no internals yet -- they land with issue #11.
* The Rplaceholder_* devices in this cell are 1 Tohm terminations, not
* design content: they exist only so this stub is ERC-clean and DC-solvable.
* Nothing in this cell may be cited as simulation evidence.

**** end user architecture code
.ends
