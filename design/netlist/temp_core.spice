* temp_core -- generated by design/netlist.py from design/temp_core.sch
* Do not edit: edit the schematic and re-run the export.
** sch_path: design/temp_core.sch
.subckt temp_core VDD VSS IBIAS EN PTAT CTAT
*.PININFO VDD:B VSS:B IBIAS:I EN:I PTAT:O CTAT:O
Rplaceholder_ptat PTAT VSS 1T m=1
Rplaceholder_ctat CTAT VSS 1T m=1
**** begin user architecture code

* PLACEHOLDER: temp_core has no internals yet -- they land with issue #9.
* The Rplaceholder_* devices in this cell are 1 Tohm terminations, not
* design content: they exist only so this stub is ERC-clean and DC-solvable.
* Nothing in this cell may be cited as simulation evidence.

**** end user architecture code
.ends
