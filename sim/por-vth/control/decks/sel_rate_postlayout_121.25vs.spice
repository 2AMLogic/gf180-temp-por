* por-vth rate-ladder control -- postlayout @ ss/-40C/3.63V, tramp=13.4433 ms (121.2 V/s) -- GENERATED by run_rate_ladder.py, do not edit
* pdk=gf180mcuD@c6d73a35f524070e85faff4a6a9eef49553ebc2b  harness=0.1.0

.param vdd_nom=3.3
.param vdd_val=3.63
.param temp_c=-40.0
.param tramp=0.013443298969072164

.include "/Users/rwalters/.volare/gf180mcuD/libs.tech/ngspice/design.ngspice"
.lib "/Users/rwalters/.volare/gf180mcuD/libs.tech/ngspice/sm141064.ngspice" ss
.lib "/Users/rwalters/.volare/gf180mcuD/libs.tech/ngspice/sm141064.ngspice" res_ss
.lib "/Users/rwalters/.volare/gf180mcuD/libs.tech/ngspice/sm141064.ngspice" bjt_ss
.lib "/Users/rwalters/.volare/gf180mcuD/libs.tech/ngspice/sm141064.ngspice" diode_ss
.lib "/Users/rwalters/.volare/gf180mcuD/libs.tech/ngspice/sm141064.ngspice" moscap_ss
.lib "/Users/rwalters/.volare/gf180mcuD/libs.tech/ngspice/sm141064.ngspice" mimcap_ss

.temp -40.0
.options reltol=1e-5
.options abstol=1e-15
.options vntol=1e-9

.include "../rate_ladder.spice"
.include "../../../../layout/postlayout/temp_por_top.spice"

.control
set numdgt=10
set noaskquit
tran 10u 0.035886597938144325
meas tran vpor_rise find v(vdd) when v(xdut.por_raw)=1.5 rise=1
meas tran vpor_rise_last find v(vdd) when v(xdut.por_raw)=1.5 rise=last
meas tran vpor_fall find v(vdd) when v(xdut.por_raw)=1.5 fall=1
meas tran vpor_fall_last find v(vdd) when v(xdut.por_raw)=1.5 fall=last
meas tran vref_settle find v(xdut.vref) at=0.020343298969072162
.endc
.end
