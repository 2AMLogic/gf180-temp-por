* tb_por_pulse_postlayout -- GENERATED by sim/build_tb.py
* Do not edit. Sources:
*   sim/por-output-chain-pulse/testbench/stimulus.spice
*   layout/postlayout/por_output_chain.spice  (sha256 2722ab83a3bd292d5e206d3cad6543db15a79d66e338d8efeea338094a2c25cb)
* Regenerate with:
*   python3 sim/build_tb.py

* por-output-chain-pulse -- stimulus half of the testbench fragment.
*
* The other half is a verbatim copy of design/netlist/por_output_chain.spice,
* appended by sim/build_tb.py to produce tb_por_pulse.spice. Edit THIS file
* (or the schematic), never the generated fragment.
*
* Netlist FRAGMENT: no .include / .lib / .temp / .control / .end -- the
* harness owns those. Parameters it supplies: vdd_val, vdd_nom, temp_c.
*
* WHAT THIS EXPERIMENT SUBSTANTIATES
*
* spec/target-spec.md#por-reset-pulse: RESETn stays asserted for >=1 ms after
* the release conditions are met, at the FASTEST-timer corner. The pulse here
* is a current-starved ramp (2.5 nA into 6.27 pF), so "fastest" is the corner
* with the most charging current and the least capacitance -- FF / +125 C /
* 3.63 V -- and the whole 81-point grid is swept to prove that is really where
* the minimum lands rather than assuming it.
*
* It also records this cell's share of the shared spec/target-spec.md#por-iq
* budget, sampled in the state that row is defined in (rule 1 of the table's
* section 5): RESETn asserted, rail settled, sensor disabled.
*
* THE IBIAS TOLERANCE PROBLEM, AND WHY THERE ARE TWO DUTS
*
* Every internal current in this cell is a ratio of IBIAS, so the pulse width
* scales as 1/IBIAS. bias_core (#11) has not landed, so its corner spread is
* not yet knowable; asserting >=1 ms against one ideal 0.5 uA source would be
* a result that #11 could silently invalidate later. Instead two identical
* DUTs run side by side on the same rail:
*
*   xdut1  IBIAS = 0.5 uA   the DR-005 nominal (same convention as temp_core:
*                           bias_core SOURCES the current into the pin)
*   xdut2  IBIAS = 1.5 uA   3x nominal -- the stress case for the >=1 ms
*                           minimum, since more bias current means a faster
*                           timer. If xdut2 clears 1 ms at every corner then
*                           the claim survives a 3x IBIAS error from #11.
*
* TIMELINE
*
*   0     -> 100 us   VDD ramps 0 -> vdd_val (~33 kV/s, inside the ratified
*                     por-ramp-rate envelope). POR_RAW held low.
*   100 us-> 1 ms     rail settled, POR_RAW low: this is exactly the por-iq
*                     accounting state. Sampled at 0.9 ms.
*   1.001 ms          POR_RAW steps high -- the release condition. Stepping it
*                     rather than deriving it from the ramp is deliberate: the
*                     pulse is measured from a single unambiguous t0, and
*                     ramp-crossing behaviour is #14's job, not this record's.
*   ...               RESETn must stay low for >=1 ms, then release once.
*   19.5 ms           released-state draw sampled (feeds iq-total, not por-iq)

vsup vdd 0 PWL(0 0 100u {vdd_val} 20m {vdd_val})
vpr  por_raw 0 PWL(0 0 1m 0 1.002m {vdd_val} 20m {vdd_val})

* IBIAS references. Modelled as coming up with the rail rather than as ideal
* DC sources: below ~1.5 V there is no bias core yet (DR-005 startup ordering
* step 3), so forcing current into the pin while the rail is dead would be a
* stimulus artefact. Same construction as sim/temp-core-startup/.
Bib1 vdd nib1 i='500n*min(1, max(0, (v(vdd)-1.5)/0.5))'
vib1 nib1 ibias1 dc 0
Bib2 vdd nib2 i='1500n*min(1, max(0, (v(vdd)-1.5)/0.5))'
vib2 nib2 ibias2 dc 0

* 0 V ammeters in each DUT's own VDD pin. The IBIAS reference is sourced from
* vdd directly, so it does NOT pass through these -- i(vd1) is what this cell
* draws from the rail on its own account, which is the number the por-iq
* budget needs.
vd1 vdd vdd1 dc 0
vd2 vdd vdd2 dc 0

* por-reset-pulse measurement load, provisional per the spec row: 5 pF, no DC
* load. The 1 Tohm is a solver aid, not a load.
Cl1 resetn1 0 5p
Rl1 resetn1 0 1T
Cl2 resetn2 0 5p
Rl2 resetn2 0 1T

xdut1 vdd1 0 ibias1 por_raw resetn1 por_output_chain
xdut2 vdd2 0 ibias2 por_raw resetn2 por_output_chain

* por_output_chain -- post-layout netlist
* GENERATED by layout/postlayout.py -- do not edit.
*
* FROM THE LAYOUT: every device and its dimensions, the whole
*   topology, and first-order interconnect R/C on 18/30 nets
*   (sigma 828.6 fF). klt 0.2.0, deck gf180mcu,
*   GDS sha256 475c7feaa83591e1...
* Net names are the schematic's, restored through klt lvs's own net
*   correspondence -- match, 30/30 nets, every one paired.
*
* NOT FROM THE LAYOUT -- see layout/postlayout/AUDIT.md:
*   12 body/plate net(s) tied to the net the schematic puts
*   them on. The extraction deck's connectivity stack does not reach
*   an Nwell, a substrate ring, a bipolar base well or a MiM plate,
*   so they extract isolated and would otherwise float.
*   No ideal device: every golden device is drawn.
*
.subckt por_output_chain VDD VSS IBIAS POR_RAW RESETn

* --- drawn devices ---
X1 PDN IBIAS VSS VSS nfet_03v3 L=25u W=0.5u nf=1 ad=0.4p as=0.4p pd=2.6u ps=2.6u m=1
X2 PGDGB PGDG VSS VSS nfet_03v3 L=2u W=0.5u nf=1 ad=0.4p as=0.4p pd=2.6u ps=2.6u m=1
X3 ND1 NDL VSS VSS nfet_03v3 L=10u W=0.5u nf=1 ad=0.4p as=0.4p pd=2.6u ps=2.6u m=1
X4 NDG POR_RAW NDGN VSS nfet_03v3 L=0.5u W=1u nf=1 ad=0.8p as=0.8p pd=3.6u ps=3.6u m=1
X5 TIM PGDGB VSS VSS nfet_03v3 L=1u W=1u nf=1 ad=0.8p as=0.8p pd=3.6u ps=3.6u m=1
X6 TRIP ND1 VSS VSS nfet_03v3 L=1u W=1u nf=1 ad=0.8p as=0.8p pd=3.6u ps=3.6u m=1
X7 ND1 RESETn VSS VSS nfet_03v3 L=1u W=1u nf=1 ad=0.8p as=0.8p pd=3.6u ps=3.6u m=1
X8 NDL NDL VSS VSS nfet_03v3 L=10u W=2u nf=1 ad=1.6p as=1.6p pd=5.6u ps=5.6u m=1
X9 PGDG NDG VSS VSS nfet_03v3 L=0.5u W=2u nf=1 ad=1.6p as=1.6p pd=5.6u ps=5.6u m=1
X10 RSTB TRIP NNAND VSS nfet_03v3 L=0.5u W=2u nf=1 ad=1.6p as=1.6p pd=5.6u ps=5.6u m=1
X11 NNAND PGDG VSS VSS nfet_03v3 L=0.5u W=2u nf=1 ad=1.6p as=1.6p pd=5.6u ps=5.6u m=1
X12 IBIAS IBIAS VSS VSS nfet_03v3 L=4u W=4u nf=1 ad=3.2p as=3.2p pd=9.6u ps=9.6u m=1
X13 NDGN NDL VSS VSS nfet_03v3 L=10u W=10u nf=1 ad=8p as=8p pd=21.6u ps=21.6u m=1
X14 RESETn RSTB VSS VSS nfet_03v3 L=0.5u W=10u nf=1 ad=8p as=8p pd=21.6u ps=21.6u m=1
X15 NTS PDN VDD VDD pfet_03v3 L=10u W=0.5u nf=1 ad=0.4p as=0.4p pd=2.6u ps=2.6u m=1
X16 TRIP PDN VDD VDD pfet_03v3 L=10u W=0.5u nf=1 ad=0.4p as=0.4p pd=2.6u ps=2.6u m=1
X17 PGDG NDG VDD VDD pfet_03v3 L=2u W=0.5u nf=1 ad=0.4p as=0.4p pd=2.6u ps=2.6u m=1
X18 RSTB RESETn VDD VDD pfet_03v3 L=10u W=0.5u nf=1 ad=0.4p as=0.4p pd=2.6u ps=2.6u m=1
X19 NDG POR_RAW NDGP VDD pfet_03v3 L=0.5u W=1u nf=1 ad=0.8p as=0.8p pd=3.6u ps=3.6u m=1
X20 RESETn RSTB VDD VDD pfet_03v3 L=1u W=1u nf=1 ad=0.8p as=0.8p pd=3.6u ps=3.6u m=1
X21 PDN PDN VDD VDD pfet_03v3 L=10u W=2u nf=1 ad=1.6p as=1.6p pd=5.6u ps=5.6u m=1
X22 NDL PDN VDD VDD pfet_03v3 L=10u W=2u nf=1 ad=1.6p as=1.6p pd=5.6u ps=5.6u m=1
X23 PGDGB PGDG VDD VDD pfet_03v3 L=0.5u W=2u nf=1 ad=1.6p as=1.6p pd=5.6u ps=5.6u m=1
X24 TIM PGDGB NTS VDD pfet_03v3 L=1u W=2u nf=1 ad=1.6p as=1.6p pd=5.6u ps=5.6u m=1
X25 ND1 TIM VDD VDD pfet_03v3 L=1u W=2u nf=1 ad=1.6p as=1.6p pd=5.6u ps=5.6u m=1
X26 RSTB TRIP VDD VDD pfet_03v3 L=0.5u W=4u nf=1 ad=3.2p as=3.2p pd=9.6u ps=9.6u m=1
X27 RSTB PGDG VDD VDD pfet_03v3 L=0.5u W=4u nf=1 ad=3.2p as=3.2p pd=9.6u ps=9.6u m=1
X28 NDGP PDN VDD VDD pfet_03v3 L=10u W=10u nf=1 ad=8p as=8p pd=21.6u ps=21.6u m=1
X29 NDG VSS cap_mim_2f0_m3m4_noshield c_width=11u c_length=11u
X30 TIM VSS cap_mim_2f0_m3m4_noshield c_width=28u c_length=28u
X31 TIM VSS cap_mim_2f0_m3m4_noshield c_width=28u c_length=28u
X32 TIM VSS cap_mim_2f0_m3m4_noshield c_width=28u c_length=28u
X33 TIM VSS cap_mim_2f0_m3m4_noshield c_width=28u c_length=28u

R_10 NDGN NDGN__par 3937.0807
C_10 NDGN__par VSS 3.4262384e-14
R_11 NDG NDG__par 4070.1194
C_11 NDG__par VSS 3.8582127e-14
R_12 PGDG PGDG__par 4189.4122
C_12 PGDG__par VSS 4.2342204e-14
R_13 TIM TIM__par 4003.4777
C_13 TIM__par VSS 3.7210339e-14
R_14 TRIP TRIP__par 4060.1793
C_14 TRIP__par VSS 3.9476253e-14
R_15 NNAND NNAND__par 3939.9598
C_15 NNAND__par VSS 3.5425418e-14
R_16 NDGP NDGP__par 3936.7209
C_16 NDGP__par VSS 3.4117005e-14
R_17 RSTB RSTB__par 4076.1659
C_17 RSTB__par VSS 4.4250826e-14
R_2 PDN PDN__par 4872.473
C_2 PDN__par VSS 5.6524204e-14
R_3 NDL NDL__par 4462.4943
C_3 NDL__par VSS 4.7374149e-14
R_5 PGDGB PGDGB__par 4066.8624
C_5 PGDGB__par VSS 3.8940744e-14
R_6 ND1 ND1__par 4009.3404
C_6 ND1__par VSS 3.953615e-14
R_8 NTS NTS__par 3938.5202
C_8 NTS__par VSS 3.4843901e-14
RIBIAS IBIAS IBIAS__par 4398.6611
CIBIAS IBIAS__par VSS 4.5280553e-14
RPOR_RAW POR_RAW POR_RAW__par 4047.2842
CPOR_RAW POR_RAW__par VSS 3.435215e-14
RRESETn RESETn RESETn__par 4167.0798
CRESETn RESETn__par VSS 4.4306787e-14
RVDD VDD VDD__par 79.7582
CVDD VDD__par VSS 6.9000979e-14
RVSS VSS VSS__par 66.7327
CVSS VSS__par VSS 1.12754344e-13
.ends por_output_chain
