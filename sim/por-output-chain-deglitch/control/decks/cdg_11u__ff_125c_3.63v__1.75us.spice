* por-output-chain-deglitch CDG tradeoff -- XCDG 11u x 11u @ ff / 125 C / 3.63 V, 1.75 us dip -- GENERATED by run_cdg_tradeoff.py, do not edit
* pdk=gf180mcuD@c6d73a35f524070e85faff4a6a9eef49553ebc2b

.param vdd_val=3.63
.param t_dip_lo=0.0009999
.param t_dip_hi=0.001
.param t_dip_end=0.00100175
.param t_dip_up=0.00100185
.param stop_s=0.0011

.include "/home/ubuntu/.volare/gf180mcuD/libs.tech/ngspice/design.ngspice"
.lib "/home/ubuntu/.volare/gf180mcuD/libs.tech/ngspice/sm141064.ngspice" ff
.lib "/home/ubuntu/.volare/gf180mcuD/libs.tech/ngspice/sm141064.ngspice" res_ff
.lib "/home/ubuntu/.volare/gf180mcuD/libs.tech/ngspice/sm141064.ngspice" bjt_ff
.lib "/home/ubuntu/.volare/gf180mcuD/libs.tech/ngspice/sm141064.ngspice" diode_ff
.lib "/home/ubuntu/.volare/gf180mcuD/libs.tech/ngspice/sm141064.ngspice" moscap_ff
.lib "/home/ubuntu/.volare/gf180mcuD/libs.tech/ngspice/sm141064.ngspice" mimcap_ff

.temp 125.0
.options reltol=1e-5
.options abstol=1e-15
.options vntol=1e-8
.options method=gear

.include "../cdg_tradeoff.spice"
.include "dut_cdg_11u.spice"

.tran 2e-08 {stop_s}

.meas tran timbefore find v(xdut1.tim) at=0.000999
.meas tran pgdgmin min v(xdut1.pgdg) from=0.0009999 to=0.0010417500000000001
.meas tran timafter min v(xdut1.tim) from=0.0009999 to=0.0010417500000000001
.meas tran tpgf1 when v(xdut1.pgdg)=1.0 fall=1 td=0.0009999
.meas tran tpgf2 when v(xdut2.pgdg)=1.0 fall=1 td=0.0009999

.end
