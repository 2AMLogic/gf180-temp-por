* por-brownout-spurious -- stimulus half of the testbench fragment.
*
* The other half is a verbatim copy of design/netlist/temp_por_top.spice,
* appended by sim/build_tb.py to produce tb_por_brownout_spurious.spice. Edit
* THIS file (or the schematics), never the generated fragment.
*
* Netlist FRAGMENT: no .include / .lib / .temp / .control / .end -- the
* harness owns those. Parameters it supplies: vdd_val, vdd_nom, temp_c.
*
* WHAT THIS EXPERIMENT SUBSTANTIATES (#61)
*
* sim/por-brownout/control/results.md Part B (one point, tt/27 C/3.30 V)
* found that at INTERMEDIATE falling-edge rates -- slower than the DR-011
* boundary that leaves RESETn latched at the dip rail (~7.67-11.50 mV/us),
* but faster than the slowest control point (0.77 mV/us, which asserted
* correctly inside the ratified VPOR-downarrow band) -- POR_RAW asserts at a
* rail 300-700+ mV ABOVE VPOR-uparrow,max = 2.73 V:
*
*     7.67 mV/us (0.3 ms edge)  ->  2.9941 V   (spurious)
*     2.30 mV/us (1.0 ms edge)  ->  3.1385 V   (spurious)
*     0.77 mV/us (3.0 ms edge)  ->  2.3828 V   (correct, in VPOR-downarrow band)
*
* That is a reset asserted while the rail is still comfortably inside the
* ratified operating range -- a DISTINCT defect from #55/DR-011's "RESETn
* never leaves the dip rail" finding (that is a fast-edge, sub-7.67 mV/us
* phenomenon; this is an intermediate-edge, ~0.5-5 mV/us phenomenon), and
* from #56's rising-edge release chatter. This deck confirms or refutes it
* on the full 81-point PVT grid (control B ran ONE point, per
* sim/README.md's "a control never substantiates a spec row").
*
* THREE PARALLEL DUTs, ONE TRANSIENT, sharing one time axis -- the same
* multi-branch idiom sim/por-ramp-rate/testbench/stimulus.spice already uses,
* so this record and #60's own falling-slew-boundary sweep are not two
* separate 81-point corner grids for what is fundamentally one dip topology
* swept over edge rate. Each branch xb1/xb3/xb6 is a full four-cell assembly
* on its own dip, differing ONLY in the falling/rising edge duration, and
* reproduces the control's own three Part-B points exactly (branch numbering
* kept as xb1/xb3/xb6, not renumbered, so this deck's branches map 1:1 onto
* the control's own row labels and this file's own header comment above):
*
*   xb1   0.3 ms edge   (tt/27C/3.3V slew 7.67 mV/us -- control's spurious pt)
*   xb3   1.0 ms edge   (tt/27C/3.3V slew 2.30 mV/us -- control's spurious pt)
*   xb6   3.0 ms edge   (tt/27C/3.3V slew 0.77 mV/us -- control's correct pt)
*
* Originally six branches (adding 0.5/1.5/2.0 ms edges to bracket the
* transition more finely); trimmed to these three under a documented
* resource constraint -- see the record's own environment note and
* spec/decision-records/DR-013-por-brownout-spurious-assert.md's
* Consequences section. The three retained points are sufficient for this
* issue's own acceptance criteria (confirm/refute on the full grid, and
* whether the assert rail is bounded vs. tracks VDD, both readable from a
* spurious/spurious/correct bracket); the finer transition boundary between
* 0.77 and 2.30 mV/us is explicitly left uncharacterized by this record.
*
* Deliberately NOT included: edges faster than 0.3 ms. Those approach and
* cross DR-011's own boundary (measured 7.67-11.50 mV/us at ONE point, and
* explicitly "strongly corner-dependent" per DR-011) from the wrong side --
* at some corners RESETn may not leave the dip rail at all for such an edge,
* which is #60's characterization to make, not a second, uncoordinated
* attempt at the same boundary here.
*
* DIP SHAPE: each branch reuses sim/por-brownout/control/dip_shape.spice's
* own family (1 ms cold start, held to 20 ms, dip to 1.0 V -- the same depth
* the parent sim/por-brownout/ record and its control use -- for its own
* edge duration, a fixed 50 us dwell at the floor matching the control's own
* T_DWELL_MS, then recovery to vdd_val over the SAME edge duration).
* T_DIP = 20 ms is shared by every branch (sim/por-brownout/'s own dip start,
* by which point sim/temp-por-top-release/ has RESETn released at all 81
* corners with 3 ms of margin).
*
* PAD LOAD: 1 pF plus a 1 Tohm DC leak on each of PTAT and CTAT, per branch,
* matching sim/por-brownout/testbench/stimulus.spice and
* sim/temp-por-top-release/ exactly -- see that file's header for why
* (ngspice's local truncation error control otherwise collapses the
* timestep tracking the disabled-consumer floating pads; 1 Tohm at a
* ~1.3 V pad is 1.3 pA, far below the block's own nanoamp-scale currents).
*
* TIMESTEP / RUN LENGTH: `tran 20u 55m`, identical to
* sim/por-brownout/testbench/stimulus.spice. The slowest branch (xb6, 3 ms
* edge) completes its recovery ramp by 26.05 ms, leaving ~29 ms of settle
* observation -- comparable margin to the parent deck's ~35 ms tail after
* its single (1 us edge) branch's dip completes at 20.052 ms.
*
* MEASUREMENT: rail-NORMALISED POR_RAW, exactly as
* sim/por-brownout/control/run_dip_rootcause.py's `praw_r` -- an absolute
* threshold is meaningless here because during the dip the rail itself is
* 1.0-3.63 V, so "v(por_raw) crosses 1.5 V" would be satisfied by POR_RAW
* simply riding the falling rail down while still a solid logic HIGH. Per
* branch: the rail-normalised crossing instant (t_praw_bN), the rail voltage
* at that instant (vdd_at_praw_bN -- THE quantity #61 asks for), and VREF at
* that same instant (vref_at_praw_bN, diagnostic: tests whether the assert
* rail correlates with an elevated reference, the signature
* design/bias_core.md's ramp-rate feedthrough term would leave). `fall=1`
* (first falling crossing) is unambiguous: POR_RAW only ever asserts once
* per run in this topology, whether that happens during the dip itself or
* -- for edges near enough to DR-011's boundary -- on the recovery ramp
* instead (the ALREADY-OWNED #55/DR-011 finding, not this issue's). Distinguishing
* the two is a simple comparison of t_praw_bN against each branch's own
* (fixed, known-at-design-time) dip window, done in the record's own write-up
* rather than in-deck, since no branch in this A/B bracket is expected to
* miss the dip window entirely (unlike DR-011's own faster-edge boundary
* region, which this deck deliberately avoids -- see above).

vb1 vddb1 0 PWL(
+ 0        0
+ 1m       {vdd_val}
+ 20m      {vdd_val}
+ 20.3m    1.0
+ 20.35m   1.0
+ 20.65m   {vdd_val}
+ )
Cppb1 ptatb1 0 1p
Cpcb1 ctatb1 0 1p
Rlpb1 ptatb1 0 1T
Rlcb1 ctatb1 0 1T
Crnb1 resetnb1 0 5p
xb1 vddb1 0 ptatb1 ctatb1 resetnb1 temp_por_top

vb3 vddb3 0 PWL(
+ 0        0
+ 1m       {vdd_val}
+ 20m      {vdd_val}
+ 21.0m    1.0
+ 21.05m   1.0
+ 22.05m   {vdd_val}
+ )
Cppb3 ptatb3 0 1p
Cpcb3 ctatb3 0 1p
Rlpb3 ptatb3 0 1T
Rlcb3 ctatb3 0 1T
Crnb3 resetnb3 0 5p
xb3 vddb3 0 ptatb3 ctatb3 resetnb3 temp_por_top

vb6 vddb6 0 PWL(
+ 0        0
+ 1m       {vdd_val}
+ 20m      {vdd_val}
+ 23.0m    1.0
+ 23.05m   1.0
+ 26.05m   {vdd_val}
+ )
Cppb6 ptatb6 0 1p
Cpcb6 ctatb6 0 1p
Rlpb6 ptatb6 0 1T
Rlcb6 ctatb6 0 1T
Crnb6 resetnb6 0 5p
xb6 vddb6 0 ptatb6 ctatb6 resetnb6 temp_por_top
