* Frozen netlist snapshot for record 20260819-182610-a4eebe7
* source     : sim/temp-core-loop-stability/testbench/tb_temp_core_loop_stability.spice
* sha256     : 2b29e635e963dec68fe960c0144710bba5500b27efd6b8c530528d02f3822197
* This is a verbatim copy taken at record time. Do not edit.
* tb_temp_core_loop_stability -- HAND-MAINTAINED, not sim/build_tb.py output.
*
* Every other sim/*/testbench/tb_*.spice fragment is generated by
* sim/build_tb.py: a verbatim, sha256-tracked copy of one design/netlist/
* export appended after a hand-written stimulus half. That mechanism cannot
* produce this fragment -- issue #274 needs the loop physically opened at
* the internal node PG, which means editing three lines *inside* the
* temp_core subcircuit body, not just wiring its unedited ports. A verbatim
* copy has nothing to attach an edit to, so this file is a hand-maintained
* fork of the subcircuit instead, kept in sync with the schematic export by
* the "Provenance / resync" note below rather than by build_tb.py --check.
*
* ---- Method -------------------------------------------------------------
*
* design/temp_core.md ("Topology", "Error amplifier") describes a single
* negative-feedback loop: the amplifier (XMI1/XMI2 input pair -> XML1/XML2
* mirror load -> XMS2N/XMS2P second stage) drives its output node PG, which
* is the gate of the cascoded PMOS mirror legs XMP1/XMP2 (NOT XMP3 -- that
* leg only reads PG out to the PTAT pad, a dead-end replica branch that does
* not feed back into the amplifier's own inputs, see below). XMP1/XMP2's
* drain currents set V(NA)/V(NB), the amplifier's own inputs, closing the
* loop: NA,NB -> amplifier -> PG -> XMP1,XMP2 -> NA,NB.
*
* This fragment forks the two PG net segments the loop actually depends on:
*   - PG stays exactly as design/netlist/temp_core.spice has it: the
*     amplifier's own output (XMS2N/XMS2P drains), the Miller compensation
*     network (XCC/XRZ), the startup devices that terminate ON that node
*     (XMENPG, XMSU3's drain, XMSU4's gate), and -- deliberately left
*     attached here rather than moved -- XMP3's gate, so the loop-defining
*     side keeps the same real capacitive loading temp_core.spice has: XMP3
*     is a matched dead-end reader of PG, not part of the feedback path, so
*     whether its gate cap sits on this side or the far side of the break
*     does not change the measured loop gain, and leaving it here avoids
*     redistributing loading that the real chip does not redistribute.
*   - PG_FB is new: only XMP1's and XMP2's gates, i.e. exactly the two
*     connections that close the loop back through NA/NB. It is broken out
*     as a 7th subcircuit port so the testbench (stimulus half, below) can
*     inject an AC test signal onto it from outside.
*
* stimulus.spice bridges PG (probed from outside via the internal dot-path
* v(xdut.pg), same idiom sim/temp-core-designer-check/testbench/tb_temp_core
* .spice already uses for v(xdut.nb) etc.) and PG_FB with a single voltage
* source, DC 0 / AC 1. At DC that source is indistinguishable from the wire
* it replaces -- V(PG_FB) - V(xdut.pg) = 0 forces the exact same equality a
* real single node PG would have, so the closed-loop DC operating point is
* unchanged (see sim/temp-core-loop-stability/README or the record's own
* edge-case comparison against sim/temp-core-designer-check for the check).
* At the AC test frequency the source forces V(PG_FB) - V(xdut.pg) = 1<0deg
* exactly, regardless of the loading either side presents -- and because the
* two node voltages that result are both linear in that same forcing
* function, their RATIO does not depend on the source's arbitrary 1 V
* amplitude or which of its two terminals is "+": T(jw) = V(xdut.pg)/
* V(pg_fb) is the closed-loop-equivalent, open-loop small-signal gain
* around the entire loop, independent of injection polarity. testbench/
* tb.json's `analyses` measure it exactly this way (vdb()/vp() difference,
* not a synthetic ratio node).
*
* ---- Provenance / resync -------------------------------------------------
*
* Forked from design/netlist/temp_core.spice (sha256
* c017e15399812a21ff04ac037d785e3c6b1fa77b5b0c45080fcacf6b9a5e64d4, the same
* export sim/temp-core-designer-check/testbench/tb_temp_core.spice's header
* cites as of this writing) by hand, changing exactly:
*   1. `.subckt temp_core VDD VSS IBIAS EN PTAT CTAT` ->
*      `.subckt temp_core_loopbreak VDD VSS IBIAS EN PTAT CTAT PG_FB`
*      (rename + one new port, so this can never be confused with the real
*      exported temp_core.spice or accidentally instantiated in its place)
*   2. `XMP1 M1D PG VDD VDD ...` -> `XMP1 M1D PG_FB VDD VDD ...`
*   3. `XMP2 M2D PG VDD VDD ...` -> `XMP2 M2D PG_FB VDD VDD ...`
*   4. `.ends` -> `.ends temp_core_loopbreak`
* Nothing else in the subcircuit body was touched. If design/temp_core.sch
* changes in a way that moves the amplifier topology (new/renamed devices
* around PG, NA, NB, XMP1/XMP2), re-diff this file against the current
* design/netlist/temp_core.spice and re-apply the same four edits by hand;
* `python3 sim/build_tb.py --check` cannot catch drift here since this
* fragment is deliberately outside that mechanism.
*
* Netlist FRAGMENT: no .include / .lib / .temp / .control / .end -- the
* harness owns those (sim/harness/README.md). Parameters it supplies:
* vdd_val, vdd_nom, temp_c.

* ---- stimulus: one enabled DUT, PG broken out for AC injection ----------
* Effectively-unloaded pads (1 Tohm), same convention
* sim/temp-core-designer-check/testbench/stimulus.spice branch 1 uses, so
* this record's DC operating point is directly comparable to that one's.
vsup  vdd 0 dc {vdd_val}
ven   en  0 dc {vdd_val}
xdut  vdd 0 ibias en ptat ctat pg_fb temp_core_loopbreak
ibref vdd ibias dc 500n
Rlp   ptat 0 1T
Rlc   ctat 0 1T

* Loop-break injection: DC 0 (so the DC operating point is unaffected, per
* the algebra above) / AC 1 (the small-signal stimulus the .ac sweep uses).
vac   pg_fb xdut.pg dc 0 ac 1

* temp_core_loopbreak -- hand-forked from design/netlist/temp_core.spice
* (see header above for exactly what changed and why).
** sch_path: design/temp_core.sch (temp_core_loopbreak is a fork, not a
** re-export; do not regenerate this block from netlist.py)
.subckt temp_core_loopbreak VDD VSS IBIAS EN PTAT CTAT PG_FB
*.PININFO VDD:B VSS:B IBIAS:I EN:I PTAT:O CTAT:O PG_FB:I
XMBD IBIAS NBG VSS VSS nfet_03v3 L=2u W=4u nf=1 ad='int((nf+1)/2) * W/nf * 0.18u' as='int((nf+2)/2) * W/nf * 0.18u' pd='2*int((nf+1)/2) * (W/nf + 0.18u)'
+ ps='2*int((nf+2)/2) * (W/nf + 0.18u)' nrd='0.18u / W' nrs='0.18u / W' sa=0 sb=0 sd=0 m=1
XMPASS IBIAS EN NBG VSS nfet_03v3 L=0.5u W=2u nf=1 ad='int((nf+1)/2) * W/nf * 0.18u' as='int((nf+2)/2) * W/nf * 0.18u' pd='2*int((nf+1)/2) * (W/nf + 0.18u)'
+ ps='2*int((nf+2)/2) * (W/nf + 0.18u)' nrd='0.18u / W' nrs='0.18u / W' sa=0 sb=0 sd=0 m=1
XMDNB NBG ENB VSS VSS nfet_03v3 L=0.5u W=2u nf=1 ad='int((nf+1)/2) * W/nf * 0.18u' as='int((nf+2)/2) * W/nf * 0.18u' pd='2*int((nf+1)/2) * (W/nf + 0.18u)'
+ ps='2*int((nf+2)/2) * (W/nf + 0.18u)' nrd='0.18u / W' nrs='0.18u / W' sa=0 sb=0 sd=0 m=1
XMBN1 PB NBG VSS VSS nfet_03v3 L=2u W=4u nf=1 ad='int((nf+1)/2) * W/nf * 0.18u' as='int((nf+2)/2) * W/nf * 0.18u' pd='2*int((nf+1)/2) * (W/nf + 0.18u)'
+ ps='2*int((nf+2)/2) * (W/nf + 0.18u)' nrd='0.18u / W' nrs='0.18u / W' sa=0 sb=0 sd=0 m=1
XMBP PB PB VDD VDD pfet_03v3 L=4u W=10u nf=1 ad='int((nf+1)/2) * W/nf * 0.18u' as='int((nf+2)/2) * W/nf * 0.18u' pd='2*int((nf+1)/2) * (W/nf + 0.18u)'
+ ps='2*int((nf+2)/2) * (W/nf + 0.18u)' nrd='0.18u / W' nrs='0.18u / W' sa=0 sb=0 sd=0 m=1
XMBN2 PCAS NBG VSS VSS nfet_03v3 L=2u W=4u nf=1 ad='int((nf+1)/2) * W/nf * 0.18u' as='int((nf+2)/2) * W/nf * 0.18u' pd='2*int((nf+1)/2) * (W/nf + 0.18u)'
+ ps='2*int((nf+2)/2) * (W/nf + 0.18u)' nrd='0.18u / W' nrs='0.18u / W' sa=0 sb=0 sd=0 m=1
XMCB PCAS PCAS VDD VDD pfet_03v3 L=8u W=1u nf=1 ad='int((nf+1)/2) * W/nf * 0.18u' as='int((nf+2)/2) * W/nf * 0.18u' pd='2*int((nf+1)/2) * (W/nf + 0.18u)'
+ ps='2*int((nf+2)/2) * (W/nf + 0.18u)' nrd='0.18u / W' nrs='0.18u / W' sa=0 sb=0 sd=0 m=1
XMINVP ENB EN VDD VDD pfet_03v3 L=0.5u W=2u nf=1 ad='int((nf+1)/2) * W/nf * 0.18u' as='int((nf+2)/2) * W/nf * 0.18u' pd='2*int((nf+1)/2) * (W/nf + 0.18u)'
+ ps='2*int((nf+2)/2) * (W/nf + 0.18u)' nrd='0.18u / W' nrs='0.18u / W' sa=0 sb=0 sd=0 m=1
XMINVN ENB EN VSS VSS nfet_03v3 L=0.5u W=1u nf=1 ad='int((nf+1)/2) * W/nf * 0.18u' as='int((nf+2)/2) * W/nf * 0.18u' pd='2*int((nf+1)/2) * (W/nf + 0.18u)'
+ ps='2*int((nf+2)/2) * (W/nf + 0.18u)' nrd='0.18u / W' nrs='0.18u / W' sa=0 sb=0 sd=0 m=1
XMT NT PB VDD VDD pfet_03v3 L=4u W=20u nf=1 ad='int((nf+1)/2) * W/nf * 0.18u' as='int((nf+2)/2) * W/nf * 0.18u' pd='2*int((nf+1)/2) * (W/nf + 0.18u)'
+ ps='2*int((nf+2)/2) * (W/nf + 0.18u)' nrd='0.18u / W' nrs='0.18u / W' sa=0 sb=0 sd=0 m=1
XMI1 N1 NA NT NT pfet_03v3 L=4u W=32u nf=1 ad='int((nf+1)/2) * W/nf * 0.18u' as='int((nf+2)/2) * W/nf * 0.18u' pd='2*int((nf+1)/2) * (W/nf + 0.18u)'
+ ps='2*int((nf+2)/2) * (W/nf + 0.18u)' nrd='0.18u / W' nrs='0.18u / W' sa=0 sb=0 sd=0 m=1
XMI2 N2 NB NT NT pfet_03v3 L=4u W=32u nf=1 ad='int((nf+1)/2) * W/nf * 0.18u' as='int((nf+2)/2) * W/nf * 0.18u' pd='2*int((nf+1)/2) * (W/nf + 0.18u)'
+ ps='2*int((nf+2)/2) * (W/nf + 0.18u)' nrd='0.18u / W' nrs='0.18u / W' sa=0 sb=0 sd=0 m=1
XML1 N1 N1 VSS VSS nfet_03v3 L=8u W=8u nf=1 ad='int((nf+1)/2) * W/nf * 0.18u' as='int((nf+2)/2) * W/nf * 0.18u' pd='2*int((nf+1)/2) * (W/nf + 0.18u)'
+ ps='2*int((nf+2)/2) * (W/nf + 0.18u)' nrd='0.18u / W' nrs='0.18u / W' sa=0 sb=0 sd=0 m=1
XML2 N2 N1 VSS VSS nfet_03v3 L=8u W=8u nf=1 ad='int((nf+1)/2) * W/nf * 0.18u' as='int((nf+2)/2) * W/nf * 0.18u' pd='2*int((nf+1)/2) * (W/nf + 0.18u)'
+ ps='2*int((nf+2)/2) * (W/nf + 0.18u)' nrd='0.18u / W' nrs='0.18u / W' sa=0 sb=0 sd=0 m=1
XMS2N PG N2 VSS VSS nfet_03v3 L=8u W=8u nf=1 ad='int((nf+1)/2) * W/nf * 0.18u' as='int((nf+2)/2) * W/nf * 0.18u' pd='2*int((nf+1)/2) * (W/nf + 0.18u)'
+ ps='2*int((nf+2)/2) * (W/nf + 0.18u)' nrd='0.18u / W' nrs='0.18u / W' sa=0 sb=0 sd=0 m=1
XMS2P PG PB VDD VDD pfet_03v3 L=4u W=10u nf=1 ad='int((nf+1)/2) * W/nf * 0.18u' as='int((nf+2)/2) * W/nf * 0.18u' pd='2*int((nf+1)/2) * (W/nf + 0.18u)'
+ ps='2*int((nf+2)/2) * (W/nf + 0.18u)' nrd='0.18u / W' nrs='0.18u / W' sa=0 sb=0 sd=0 m=1
XCC PG NZ cap_mim_2f0_m3m4_noshield c_width=12u c_length=12u m=1
XRZ NZ N2 VSS ppolyf_u r_width=2u r_length=1000u m=1
XMP1 M1D PG_FB VDD VDD pfet_03v3 L=4u W=8u nf=1 ad='int((nf+1)/2) * W/nf * 0.18u' as='int((nf+2)/2) * W/nf * 0.18u' pd='2*int((nf+1)/2) * (W/nf + 0.18u)'
+ ps='2*int((nf+2)/2) * (W/nf + 0.18u)' nrd='0.18u / W' nrs='0.18u / W' sa=0 sb=0 sd=0 m=1
XMPC1 NA PCAS M1D VDD pfet_03v3 L=1u W=8u nf=1 ad='int((nf+1)/2) * W/nf * 0.18u' as='int((nf+2)/2) * W/nf * 0.18u' pd='2*int((nf+1)/2) * (W/nf + 0.18u)'
+ ps='2*int((nf+2)/2) * (W/nf + 0.18u)' nrd='0.18u / W' nrs='0.18u / W' sa=0 sb=0 sd=0 m=1
XMP2 M2D PG_FB VDD VDD pfet_03v3 L=4u W=8u nf=1 ad='int((nf+1)/2) * W/nf * 0.18u' as='int((nf+2)/2) * W/nf * 0.18u' pd='2*int((nf+1)/2) * (W/nf + 0.18u)'
+ ps='2*int((nf+2)/2) * (W/nf + 0.18u)' nrd='0.18u / W' nrs='0.18u / W' sa=0 sb=0 sd=0 m=1
XMPC2 NB PCAS M2D VDD pfet_03v3 L=1u W=8u nf=1 ad='int((nf+1)/2) * W/nf * 0.18u' as='int((nf+2)/2) * W/nf * 0.18u' pd='2*int((nf+1)/2) * (W/nf + 0.18u)'
+ ps='2*int((nf+2)/2) * (W/nf + 0.18u)' nrd='0.18u / W' nrs='0.18u / W' sa=0 sb=0 sd=0 m=1
XMP3 M3D PG VDD VDD pfet_03v3 L=4u W=8u nf=1 ad='int((nf+1)/2) * W/nf * 0.18u' as='int((nf+2)/2) * W/nf * 0.18u' pd='2*int((nf+1)/2) * (W/nf + 0.18u)'
+ ps='2*int((nf+2)/2) * (W/nf + 0.18u)' nrd='0.18u / W' nrs='0.18u / W' sa=0 sb=0 sd=0 m=1
XMPC3 PTAT PCAS M3D VDD pfet_03v3 L=1u W=8u nf=1 ad='int((nf+1)/2) * W/nf * 0.18u' as='int((nf+2)/2) * W/nf * 0.18u' pd='2*int((nf+1)/2) * (W/nf + 0.18u)'
+ ps='2*int((nf+2)/2) * (W/nf + 0.18u)' nrd='0.18u / W' nrs='0.18u / W' sa=0 sb=0 sd=0 m=1
XMSU1 ND PB VDD VDD pfet_03v3 L=8u W=1u nf=1 ad='int((nf+1)/2) * W/nf * 0.18u' as='int((nf+2)/2) * W/nf * 0.18u' pd='2*int((nf+1)/2) * (W/nf + 0.18u)'
+ ps='2*int((nf+2)/2) * (W/nf + 0.18u)' nrd='0.18u / W' nrs='0.18u / W' sa=0 sb=0 sd=0 m=1
XMSU2 ND NR VSS VSS nfet_03v3 L=2u W=2u nf=1 ad='int((nf+1)/2) * W/nf * 0.18u' as='int((nf+2)/2) * W/nf * 0.18u' pd='2*int((nf+1)/2) * (W/nf + 0.18u)'
+ ps='2*int((nf+2)/2) * (W/nf + 0.18u)' nrd='0.18u / W' nrs='0.18u / W' sa=0 sb=0 sd=0 m=1
XMSU3 PG ND VSS VSS nfet_03v3 L=1u W=4u nf=1 ad='int((nf+1)/2) * W/nf * 0.18u' as='int((nf+2)/2) * W/nf * 0.18u' pd='2*int((nf+1)/2) * (W/nf + 0.18u)'
+ ps='2*int((nf+2)/2) * (W/nf + 0.18u)' nrd='0.18u / W' nrs='0.18u / W' sa=0 sb=0 sd=0 m=1
XMDND ND ENB VSS VSS nfet_03v3 L=0.5u W=2u nf=1 ad='int((nf+1)/2) * W/nf * 0.18u' as='int((nf+2)/2) * W/nf * 0.18u' pd='2*int((nf+1)/2) * (W/nf + 0.18u)'
+ ps='2*int((nf+2)/2) * (W/nf + 0.18u)' nrd='0.18u / W' nrs='0.18u / W' sa=0 sb=0 sd=0 m=1
XMENPG PG EN VDD VDD pfet_03v3 L=0.5u W=4u nf=1 ad='int((nf+1)/2) * W/nf * 0.18u' as='int((nf+2)/2) * W/nf * 0.18u' pd='2*int((nf+1)/2) * (W/nf + 0.18u)'
+ ps='2*int((nf+2)/2) * (W/nf + 0.18u)' nrd='0.18u / W' nrs='0.18u / W' sa=0 sb=0 sd=0 m=1
XMENPT PTAT ENB VSS VSS nfet_03v3 L=1u W=1u nf=1 ad='int((nf+1)/2) * W/nf * 0.18u' as='int((nf+2)/2) * W/nf * 0.18u' pd='2*int((nf+1)/2) * (W/nf + 0.18u)'
+ ps='2*int((nf+2)/2) * (W/nf + 0.18u)' nrd='0.18u / W' nrs='0.18u / W' sa=0 sb=0 sd=0 m=1
XMENCT CTAT ENB VSS VSS nfet_03v3 L=1u W=1u nf=1 ad='int((nf+1)/2) * W/nf * 0.18u' as='int((nf+2)/2) * W/nf * 0.18u' pd='2*int((nf+1)/2) * (W/nf + 0.18u)'
+ ps='2*int((nf+2)/2) * (W/nf + 0.18u)' nrd='0.18u / W' nrs='0.18u / W' sa=0 sb=0 sd=0 m=1
XMSU4 NR PG VDD VDD pfet_03v3 L=4u W=1u nf=1 ad='int((nf+1)/2) * W/nf * 0.18u' as='int((nf+2)/2) * W/nf * 0.18u' pd='2*int((nf+1)/2) * (W/nf + 0.18u)'
+ ps='2*int((nf+2)/2) * (W/nf + 0.18u)' nrd='0.18u / W' nrs='0.18u / W' sa=0 sb=0 sd=0 m=1
XMSU5 NR NR VSS VSS nfet_03v3 L=2u W=2u nf=1 ad='int((nf+1)/2) * W/nf * 0.18u' as='int((nf+2)/2) * W/nf * 0.18u' pd='2*int((nf+1)/2) * (W/nf + 0.18u)'
+ ps='2*int((nf+2)/2) * (W/nf + 0.18u)' nrd='0.18u / W' nrs='0.18u / W' sa=0 sb=0 sd=0 m=1
XMDN2 N2 ENB VSS VSS nfet_03v3 L=1u W=2u nf=1 ad='int((nf+1)/2) * W/nf * 0.18u' as='int((nf+2)/2) * W/nf * 0.18u' pd='2*int((nf+1)/2) * (W/nf + 0.18u)'
+ ps='2*int((nf+2)/2) * (W/nf + 0.18u)' nrd='0.18u / W' nrs='0.18u / W' sa=0 sb=0 sd=0 m=1
XMDNT NT ENB VSS VSS nfet_03v3 L=1u W=2u nf=1 ad='int((nf+1)/2) * W/nf * 0.18u' as='int((nf+2)/2) * W/nf * 0.18u' pd='2*int((nf+1)/2) * (W/nf + 0.18u)'
+ ps='2*int((nf+2)/2) * (W/nf + 0.18u)' nrd='0.18u / W' nrs='0.18u / W' sa=0 sb=0 sd=0 m=1
XQ1 VSS VSS NA pnp_10p00x10p00 m=1
XQ8A VSS VSS NC pnp_10p00x10p00 m=1
XQ8B VSS VSS NC pnp_10p00x10p00 m=1
XQ8C VSS VSS NC pnp_10p00x10p00 m=1
XQ8D VSS VSS NC pnp_10p00x10p00 m=1
XQ8E VSS VSS NC pnp_10p00x10p00 m=1
XQ8F VSS VSS NC pnp_10p00x10p00 m=1
XQ8G VSS VSS NC pnp_10p00x10p00 m=1
XQ8H VSS VSS NC pnp_10p00x10p00 m=1
XR1 NB NC VSS ppolyf_u r_width=2u r_length=119.47u m=1
XR2F PTAT T5 VSS ppolyf_u r_width=2u r_length=2652.6u m=1
XR2T5 T5 T4 VSS ppolyf_u r_width=2u r_length=229.71u m=1
XR2T4 T4 T3 VSS ppolyf_u r_width=2u r_length=114.69u m=1
XR2T3 T3 T2 VSS ppolyf_u r_width=2u r_length=57.18u m=1
XR2T2 T2 T1 VSS ppolyf_u r_width=2u r_length=28.42u m=1
XR2T1 T1 T0 VSS ppolyf_u r_width=2u r_length=14.03u m=1
XR2T0 T0 VSS VSS ppolyf_u r_width=2u r_length=6.85u m=1
XRISO NA CTAT VSS ppolyf_u r_width=2u r_length=111.05u m=1
XSW5 T5 VDD T4 VSS nfet_03v3 L=0.5u W=32u nf=1 ad='int((nf+1)/2) * W/nf * 0.18u' as='int((nf+2)/2) * W/nf * 0.18u' pd='2*int((nf+1)/2) * (W/nf + 0.18u)'
+ ps='2*int((nf+2)/2) * (W/nf + 0.18u)' nrd='0.18u / W' nrs='0.18u / W' sa=0 sb=0 sd=0 m=1
XSW4 T4 VSS T3 VSS nfet_03v3 L=0.5u W=32u nf=1 ad='int((nf+1)/2) * W/nf * 0.18u' as='int((nf+2)/2) * W/nf * 0.18u' pd='2*int((nf+1)/2) * (W/nf + 0.18u)'
+ ps='2*int((nf+2)/2) * (W/nf + 0.18u)' nrd='0.18u / W' nrs='0.18u / W' sa=0 sb=0 sd=0 m=1
XSW3 T3 VSS T2 VSS nfet_03v3 L=0.5u W=32u nf=1 ad='int((nf+1)/2) * W/nf * 0.18u' as='int((nf+2)/2) * W/nf * 0.18u' pd='2*int((nf+1)/2) * (W/nf + 0.18u)'
+ ps='2*int((nf+2)/2) * (W/nf + 0.18u)' nrd='0.18u / W' nrs='0.18u / W' sa=0 sb=0 sd=0 m=1
XSW2 T2 VSS T1 VSS nfet_03v3 L=0.5u W=32u nf=1 ad='int((nf+1)/2) * W/nf * 0.18u' as='int((nf+2)/2) * W/nf * 0.18u' pd='2*int((nf+1)/2) * (W/nf + 0.18u)'
+ ps='2*int((nf+2)/2) * (W/nf + 0.18u)' nrd='0.18u / W' nrs='0.18u / W' sa=0 sb=0 sd=0 m=1
XSW1 T1 VSS T0 VSS nfet_03v3 L=0.5u W=32u nf=1 ad='int((nf+1)/2) * W/nf * 0.18u' as='int((nf+2)/2) * W/nf * 0.18u' pd='2*int((nf+1)/2) * (W/nf + 0.18u)'
+ ps='2*int((nf+2)/2) * (W/nf + 0.18u)' nrd='0.18u / W' nrs='0.18u / W' sa=0 sb=0 sd=0 m=1
XSW0 T0 VSS VSS VSS nfet_03v3 L=0.5u W=32u nf=1 ad='int((nf+1)/2) * W/nf * 0.18u' as='int((nf+2)/2) * W/nf * 0.18u' pd='2*int((nf+1)/2) * (W/nf + 0.18u)'
+ ps='2*int((nf+2)/2) * (W/nf + 0.18u)' nrd='0.18u / W' nrs='0.18u / W' sa=0 sb=0 sd=0 m=1
.ends temp_core_loopbreak
