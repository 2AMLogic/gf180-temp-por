* bias-core-startup gmin control @ tt / -40.0 C / 3.3 V -- GENERATED by run_gmin_control.py, do not edit
* gmin: 1e-9   (the one and only difference between the two decks)
* pdk=gf180mcuD@c6d73a35f524070e85faff4a6a9eef49553ebc2b

.param vdd_val=3.3

.include "/home/ubuntu/.volare/gf180mcuD/libs.tech/ngspice/design.ngspice"
.lib "/home/ubuntu/.volare/gf180mcuD/libs.tech/ngspice/sm141064.ngspice" typical
.lib "/home/ubuntu/.volare/gf180mcuD/libs.tech/ngspice/sm141064.ngspice" res_typical
.lib "/home/ubuntu/.volare/gf180mcuD/libs.tech/ngspice/sm141064.ngspice" bjt_typical
.lib "/home/ubuntu/.volare/gf180mcuD/libs.tech/ngspice/sm141064.ngspice" diode_typical
.lib "/home/ubuntu/.volare/gf180mcuD/libs.tech/ngspice/sm141064.ngspice" moscap_typical
.lib "/home/ubuntu/.volare/gf180mcuD/libs.tech/ngspice/sm141064.ngspice" mimcap_typical

.temp -40.0
.options reltol=1e-5
.options abstol=1e-15
.options vntol=1e-9
.options gmin=1e-9

.include "../gmin_control.spice"
.include "../../../../design/netlist/bias_core.spice"

.control
set numdgt=10
set noaskquit
op
print v(xdut.noko)
print v(xdut.nokl)
print v(xdut.nokx)
print v(bias_ok)
print v(vref)
print @m.xdut.xmoka.m0[id]
print @m.xdut.xmokb.m0[id]
print @m.xdut.xmol1.m0[id]
print @m.xdut.xmol2.m0[id]
.endc
.end
