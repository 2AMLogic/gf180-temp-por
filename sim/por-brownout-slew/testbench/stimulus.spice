* por-brownout-slew -- stimulus half of the testbench fragment.
* GENERATED by testbench/gen_rung.py --slew-mvus 2.45 --label 'p-slew-2.45mvus'
* Do not hand-edit -- re-run the generator to change the rung.
*
* The other half is a verbatim copy of design/netlist/temp_por_top.spice,
* appended by sim/build_tb.py to produce tb_por_brownout_slew.spice.
*
* Netlist FRAGMENT: no .include / .lib / .temp / .control / .end -- the
* harness owns those. Parameters it supplies: vdd_val, vdd_nom, temp_c.
*
* WHAT THIS RUNG SUBSTANTIATES (issue #60 / DR-011 decision 2)
*
* Same 1.0 V / 50 us qualifying dip as sim/por-brownout/'s parent record,
* with ONE variable: the falling SLEW RATE, here 2.45 mV/us --
* held CONSTANT across the whole 81-point grid by writing the PWL edge time
* as an expression in {vdd_val} (see gen_rung.py's module docstring for why
* a fixed EDGE DURATION would not do this -- the dip target is a fixed
* absolute voltage, not a fixed delta below vdd_val, so a fixed duration
* would silently vary the realized slew by supply corner).
* Depth (1.0 V) and dwell (50 us) are held fixed, well inside por-brownout's
* other two qualifying-dip clauses, per DR-011 decision 4 and control E/A
* (which already show neither is the discriminator) -- isolating slew.
*
* WHY THE RECOVERY EDGE IS STILL PRESENT: por-brownout's own 81-point
* record shows a FAILING rung's RESETn does not stay silent forever -- it
* reasserts on the RECOVERY edge (the rail RISING back to vdd_val), at
* 51.26-51.58 us after dip start on that deck's 1 us edge. Cutting the
* stimulus off at dip-end would make a failing rung's own sanity/attribution
* measurement (resetn_ratio_min_overall) read "never resolves at all",
* which is not this rung's claim -- the claim is narrower: whether it
* resolves DURING the dip. The recovery edge is included, but the long
* (35 ms) further hold sim/por-brownout/ uses to check pulse regeneration
* and chatter is NOT -- this experiment does not re-derive those.
*
* ONE DUT, ONE TRAN, staged as a timeline (illustrative edge duration shown
* at the WORST-CASE, i.e. longest, supply corner, vdd=3.63 V; the
* actual edge duration used at each grid point is computed from that
* point's own {vdd_val} so the realized SLEW, not the edge duration, is
* what stays fixed across the grid):
*
*   0    ->  1 ms       cold start: VDD ramps 0 -> vdd_val in 1 ms, exactly
*                        as sim/por-brownout/ and sim/temp-por-top-release/.
*    1   -> 20 ms       held at vdd_val -- rail settled, RESETn released.
*   20   -> ~21.0735 ms   VDD dips from vdd_val to 1 V at
*                        2.45 mV/us (1.07347 ms edge at this corner's vdd).
*   ~21.0735 -> ~21.1235 ms  held at 1 V for 50 us (50 us,
*                        sim/por-brownout/'s own qualifying dwell -- 5x T_dip,min).
*   ~21.1235 -> ~22.1969 ms  VDD recovers from 1 V to vdd_val
*                        at the same 2.45 mV/us magnitude.
*   ~22.1969 -> end  held at vdd_val -- 60 us of margin
*                        for a recovery-edge reassert to complete (see
*                        above); NOT a pulse-regeneration or chatter check.

* All .param values and PWL breakpoint expressions below are in SPICE base
* units (seconds, volts) -- no "m"/"u" suffixes on expressions -- because
* two pitfalls surfaced while developing this generator (each confirmed via
* a standalone ngspice smoke test, see the module docstring):
*   1. A ``.param`` whose RHS references ANOTHER ``.param`` (e.g.
*      ``.param t_edge = (vdd_val-dip_v)/slew_mvus``) does not evaluate on
*      this ngspice build ("Undefined parameter"/"Cannot compute
*      substitute") -- only a VALUE FIELD (a source/PWL breakpoint) may
*      combine multiple independently-defined ``.param``s via ``{...}``.
*      The edge-time formula is therefore written out in full at every
*      breakpoint instead of through an intermediate ``.param``.
*   2. Appending a literal SI suffix directly after a ``{...}`` expression
*      (e.g. ``{t_dip+t_edge}m``) re-applies that suffix to a value that,
*      if t_dip/t_edge are already in seconds, is already in base units --
*      silently scaling it by another 1e-3. Every quantity below is kept in
*      seconds throughout instead.
.param dip_v = 1.0
.param t_dip = 0.02
.param t_dwell = 5e-05
.param slew_mvus = 2.45
* mV/us is numerically V/ms (see gen_rung.py's edge_ms_at()); the *1e-3
* below converts that ms-valued ratio to the seconds every other quantity
* in this PWL is expressed in.

vsup vdd 0 PWL(
+ 0                                                                 0
+ 1e-3                                                              {vdd_val}
+ {t_dip}                                                          {vdd_val}
+ {t_dip+(vdd_val-dip_v)/slew_mvus*1e-3}                           {dip_v}
+ {t_dip+(vdd_val-dip_v)/slew_mvus*1e-3+t_dwell}                   {dip_v}
+ {t_dip+2*(vdd_val-dip_v)/slew_mvus*1e-3+t_dwell}                 {vdd_val}
+ {t_dip+2*(vdd_val-dip_v)/slew_mvus*1e-3+t_dwell+6e-05} {vdd_val}
+ )

Cpp ptat 0 1p
Cpc ctat 0 1p
Rlp ptat 0 1T
Rlc ctat 0 1T
Crn resetn 0 5p

xdut vdd 0 ptat ctat resetn temp_por_top
