* por_comparator -- post-layout netlist
* GENERATED by layout/postlayout.py -- do not edit.
*
* FROM THE LAYOUT: every device and its dimensions, the whole
*   topology, and first-order interconnect R/C on 15/18 nets
*   (sigma 526.4 fF, of which 0.057 fF is net-to-net coupling).
*   One star per net: <net> is the hub, <net>__t<k> each device
*   terminal on it, R<net>_t<k> the arm between them.
*   klt 0.6.0, deck gf180mcu,
*   GDS sha256 c60a2ef35e34d6d4...
* Net names are the schematic's, restored through klt lvs's own net
*   correspondence -- match, 18/18 nets, every one paired.
*
* NOT FROM THE LAYOUT -- see layout/postlayout/AUDIT.md:
*   3 body/plate net(s) tied to the net the schematic puts
*   them on. The extraction deck's connectivity stack does not reach
*   an Nwell, a substrate ring, a bipolar base well or a MiM plate,
*   so they extract isolated and would otherwise float.
*   No ideal device: every golden device is drawn.
*
.subckt por_comparator VDD VSS IBIAS VREF BIAS_OK POR_RAW

* --- drawn devices ---
X1 TN__t1 NBG__t0 VSS__t2 VSS nfet_03v3 L=10u W=1u nf=1 ad=0.8p as=0.8p pd=3.6u ps=3.6u m=1
X2 IBIAS__t2 BIAS_OKB__t2 VSS__t3 VSS nfet_03v3 L=1u W=1u nf=1 ad=0.8p as=0.8p pd=3.6u ps=3.6u m=1
X3 N1__t3 CMPO__t1 VSS__t5 VSS nfet_03v3 L=0.5u W=1u nf=1 ad=0.8p as=0.8p pd=3.6u ps=3.6u m=1
X4 POR_RAW__t0 N1__t2 VSS__t7 VSS nfet_03v3 L=0.5u W=1u nf=1 ad=0.8p as=0.8p pd=3.6u ps=3.6u m=1
X5 BIAS_OKB__t4 BIAS_OK__t1 VSS__t6 VSS nfet_03v3 L=0.5u W=1u nf=1 ad=0.8p as=0.5p pd=3.6u ps=3u m=1
X6 NA__t2 SNS__t1 TN__t0 VSS nfet_03v3 L=1u W=2u nf=1 ad=1.6p as=1.6p pd=5.6u ps=5.6u m=1
X7 CMPO__t2 VREF__t0 TN__t2 VSS nfet_03v3 L=1u W=2u nf=1 ad=1.6p as=1.6p pd=5.6u ps=5.6u m=1
X8 IBIAS__t0 NBG__t1 VSS__t1 VSS nfet_03v3 L=2u W=2u nf=1 ad=1.6p as=1.6p pd=5.6u ps=5.6u m=1
X9 IBIAS__t1 BIAS_OK__t2 NBG__t2 VSS nfet_03v3 L=0.5u W=2u nf=1 ad=1.6p as=1.6p pd=5.6u ps=5.6u m=1
X10 NBG__t3 BIAS_OKB__t1 VSS__t8 VSS nfet_03v3 L=0.5u W=2u nf=1 ad=1.6p as=1.6p pd=5.6u ps=5.6u m=1
X11 CMPO__t3 BIAS_OKB__t5 VSS__t9 VSS nfet_03v3 L=1u W=2u nf=1 ad=1.6p as=1.6p pd=5.6u ps=5.6u m=1
X12 SNSB__t1 N1__t1 VSS__t4 VSS nfet_03v3 L=0.5u W=10u nf=1 ad=8p as=8p pd=21.6u ps=21.6u m=1
X13 N1__t0 CMPO__t0 VDD__t1 VDD pfet_03v3 L=0.5u W=2u nf=1 ad=1.6p as=1.6p pd=5.6u ps=5.6u m=1
X14 POR_RAW__t1 N1__t4 VDD__t4 VDD pfet_03v3 L=0.5u W=2u nf=1 ad=1.6p as=1.6p pd=5.6u ps=5.6u m=1
X15 NA__t0 NA__t1 VDDA__t0 VDD pfet_03v3 L=1u W=4u nf=1 ad=3.2p as=3.2p pd=9.6u ps=9.6u m=1
X16 CMPO__t4 NA__t3 VDDA__t2 VDD pfet_03v3 L=1u W=4u nf=1 ad=3.2p as=3.2p pd=9.6u ps=9.6u m=1
X17 VDDA__t1 BIAS_OKB__t0 VDD__t0 VDD pfet_03v3 L=0.5u W=4u nf=1 ad=3.2p as=3.2p pd=9.6u ps=9.6u m=1
X18 BIAS_OKB__t3 BIAS_OK__t0 VDD__t2 VDD pfet_03v3 L=0.5u W=2u nf=1 ad=1.6p as=1p pd=5.6u ps=5u m=1
X19 SNS__t0 VDD__t3 VSS ppolyf_u_3k r_width=2u r_length=7897.44u
X20 SNSB__t0 SNS__t2 VSS ppolyf_u_3k r_width=2u r_length=6769.23u
X21 VSS__t0 SNSB__t2 VSS ppolyf_u_3k r_width=2u r_length=775u

R_10_t0 SNS__t0 SNS 122.893078864
R_10_t1 SNS__t1 SNS 686.311407462
R_10_t2 SNS__t2 SNS 684.253813674
C_10 SNS VSS 5.2672565e-14
R_12_t0 NBG__t0 NBG 715.139441326
R_12_t1 NBG__t1 NBG 44.0457601943
R_12_t2 NBG__t2 NBG 257.887617601
R_12_t3 NBG__t3 NBG 499.88258088
C_12 NBG VSS 2.1326008e-14
R_14_t0 SNSB__t0 SNSB 212.505429182
R_14_t1 SNSB__t1 SNSB 688.022546875
R_14_t2 SNSB__t2 SNSB 513.044723943
C_14 SNSB VSS 4.42629e-14
R_3_t0 VDDA__t0 VDDA 631.9122
R_3_t1 VDDA__t1 VDDA 616.937977251
R_3_t2 VDDA__t2 VDDA 14.9742227488
C_3 VDDA VSS 1.4679011e-14
R_4_t0 NA__t0 NA 288.034386996
R_4_t1 NA__t1 NA 288.034386996
R_4_t2 NA__t2 NA 692.332138375
R_4_t3 NA__t3 NA 116.445087634
C_4 NA VSS 1.5868526e-14
R_5_t0 CMPO__t0 CMPO 261.418858782
R_5_t1 CMPO__t1 CMPO 366.105615344
R_5_t2 CMPO__t2 CMPO 88.9071013133
R_5_t3 CMPO__t3 CMPO 324.899769804
R_5_t4 CMPO__t4 CMPO 340.793554757
C_5 CMPO VSS 1.7766709e-14
R_7_t0 N1__t0 N1 377.193158999
R_7_t1 N1__t1 N1 175.868361694
R_7_t2 N1__t2 N1 292.041043747
R_7_t3 N1__t3 N1 253.833596266
R_7_t4 N1__t4 N1 338.946339293
C_7 N1 VSS 1.7866109e-14
R_9_t0 TN__t0 TN 486.762381087
R_9_t1 TN__t1 TN 630.394143252
R_9_t2 TN__t2 TN 143.96957566
C_9 TN VSS 1.3588667e-14
RBIAS_OK_t0 BIAS_OK__t0 BIAS_OK 369.383580086
RBIAS_OK_t1 BIAS_OK__t1 BIAS_OK 363.218515086
RBIAS_OK_t2 BIAS_OK__t2 BIAS_OK 719.565404828
CBIAS_OK BIAS_OK VSS 1.5010689e-14
RBIAS_OKB_t0 BIAS_OKB__t0 BIAS_OKB 744.308889961
RBIAS_OKB_t1 BIAS_OKB__t1 BIAS_OKB 59.9080526262
RBIAS_OKB_t2 BIAS_OKB__t2 BIAS_OKB 17.0676522536
RBIAS_OKB_t3 BIAS_OKB__t3 BIAS_OKB 351.14495704
RBIAS_OKB_t4 BIAS_OKB__t4 BIAS_OKB 349.031750011
RBIAS_OKB_t5 BIAS_OKB__t5 BIAS_OKB 109.722398109
CBIAS_OKB BIAS_OKB VSS 2.1654538e-14
RIBIAS_t0 IBIAS__t0 IBIAS 533.695252733
RIBIAS_t1 IBIAS__t1 IBIAS 99.7987141232
RIBIAS_t2 IBIAS__t2 IBIAS 632.489533144
CIBIAS IBIAS VSS 1.5551286e-14
RPOR_RAW_t0 POR_RAW__t0 POR_RAW 630.2627
RPOR_RAW_t1 POR_RAW__t1 POR_RAW 630.2627
CPOR_RAW POR_RAW VSS 1.3389027e-14
RVDD_t0 VDD__t0 VDD 12.7336201769
RVDD_t1 VDD__t1 VDD 12.0253116944
RVDD_t2 VDD__t2 VDD 6.48776582345
RVDD_t3 VDD__t3 VDD 32.2751991947
RVDD_t4 VDD__t4 VDD 11.2386031105
CVDD VDD VSS 5.224626e-14
RVREF_t0 VREF__t0 VREF 1314.9134
CVREF VREF VSS 1.1576327e-14
RVSS_t0 VSS__t0 VSS 64.8046911939
RVSS_t1 VSS__t1 VSS 9.77195124849
RVSS_t2 VSS__t2 VSS 11.5158890497
RVSS_t3 VSS__t3 VSS 7.69448202722
RVSS_t4 VSS__t4 VSS 7.01282363789
RVSS_t5 VSS__t5 VSS 5.66535726961
RVSS_t6 VSS__t6 VSS 3.4721529129
RVSS_t7 VSS__t7 VSS 5.0403841349
RVSS_t8 VSS__t8 VSS 8.36611448231
RVSS_t9 VSS__t9 VSS 6.33425404314
CVSS VSS VSS 1.98907083e-13
Ccc__10__14 SNS SNSB 1.8889e-17
Ccc__10_BIAS_OK SNS BIAS_OK 9.444e-18
Ccc__10_BIAS_OKB SNS BIAS_OKB 9.444e-18
Ccc__10_VDD SNS VDD 9.444e-18
Ccc__14_VDD SNSB VDD 9.444e-18
Rvsubs_dctie VSS 0 1e+12
.ends por_comparator
