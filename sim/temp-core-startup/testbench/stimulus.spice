* temp-core-startup -- stimulus half of the testbench fragment.
*
* The other half is a verbatim copy of design/netlist/temp_core.spice,
* appended by sim/build_tb.py to produce tb_temp_core_startup.spice. Edit
* THIS file (or the schematic), never the generated fragment.
*
* Netlist FRAGMENT: no .include / .lib / .temp / .control / .end -- the
* harness owns those. Parameters it supplies: vdd_val, vdd_nom, temp_c.
*
* WHY THIS EXPERIMENT EXISTS
*
* A DVBE loop has a degenerate zero-current solution as well as its intended
* one, and an operating-point sweep only tells you which solution the solver
* happened to land on -- not which one silicon will sit in after a cold start
* or a brownout. The first revision of this cell used an absolute-level
* startup detector (a big NMOS with its gate on the 1x PNP's VEB) and the
* sim/temp-core-designer-check op grid caught it sitting in the dead state at
* fs/-40 C and at both resistor corners. design/temp_core.sch now uses a
* CURRENT-referenced detector instead; this testbench is the evidence that it
* actually starts, from 0 V, at every PVT point, and restarts after the rail
* collapses.
*
* TIMELINE (single DUT, driven exactly the way the top level drives it)
*
*   0     -> 1.0 ms   VDD ramps 0 -> vdd_val
*   0     -> 1.5 ms   EN low. This is the pre-POR window: RESETn is asserted,
*                     so the sensor is held off (DR-005 startup ordering,
*                     step 6). Nothing here may draw current.
*   1.4 ms            sample: pre-enable PTAT level and supply current
*   1.5 ms            EN released -- models RESETn deasserting
*   2.4 ms            sample 1: PTAT/CTAT after a cold start from 0 V
*   2.5 ms            EN pulled low, then VDD collapses to 0 by 2.6 ms
*                     (brownout: POR re-asserts before the rail goes)
*   3.0 -> 3.5 ms     VDD ramps back up
*   4.0 ms            EN released again
*   4.9 ms            sample 2: PTAT/CTAT after the restart
*
* sample 2 == sample 1 is the load-bearing check: if the loop can latch into
* its dead state, the restart is where it does it, and the two samples
* diverge instead of agreeing to a few hundred ppm.

vsup vdd 0 PWL(0 0 1m {vdd_val} 2.5m {vdd_val} 2.6m 0 3.0m 0 3.5m {vdd_val} 5m {vdd_val})
ven  en  0 PWL(0 0 1.5m 0 1.501m {vdd_val} 2.5m {vdd_val} 2.501m 0 4.0m 0 4.001m {vdd_val} 5m {vdd_val})

* IBIAS: bias_core's 0.5 uA reference, modelled as coming up with the rail
* rather than as an ideal DC source. Below ~1.5 V there is no bias core yet
* (DR-005 startup ordering, step 3), so forcing 0.5 uA into the pin while the
* rail is dead would be a stimulus artefact, not a startup test.
*
* vib is a 0 V ammeter. It has to be here: the reference is sourced from the
* same rail vsup meters, and while EN is low temp_core clamps the IBIAS pin to
* VSS -- so that 0.5 uA shows up in i(vsup) even though it is bias_core's
* current, not temp_core's. Metering it separately is what lets the pre-POR
* check be about the cell's OWN draw.
Bib vdd nib i='500n*min(1, max(0, (v(vdd)-1.5)/0.5))'
vib nib ibias dc 0

* Pads: 1 pF of pad/probe capacitance, otherwise unloaded (the cell has no
* output buffer -- see design/temp_core.md).
Cpp ptat 0 1p
Cpc ctat 0 1p
Rlp ptat 0 1T
Rlc ctat 0 1T

xdut vdd 0 ibias en ptat ctat temp_core
