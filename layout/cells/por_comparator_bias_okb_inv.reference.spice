* por_comparator_bias_okb_inv -- klt lvs reference netlist
* generated by layout/lvs_reference.py from design/netlist/por_comparator.spice
* Do not edit: edit the schematic, re-run design/netlist.py, re-run this.
.SUBCKT por_comparator_bias_okb_inv BIAS_OK BIAS_OKB VDD VSS vsubs
M1 BIAS_OKB BIAS_OK VSS vsubs nfet L=0.5U W=1U
M2 BIAS_OKB BIAS_OK VDD NW1 pfet L=0.5U W=2U
.ENDS por_comparator_bias_okb_inv
