* Frozen netlist snapshot for record 20260819-171829-b403a17
* source     : sim/temp-accuracy-mc/testbench-postlayout/tb_temp_accuracy_mc_postlayout.spice
* sha256     : ccaddecdc5c9478ad768a615ed9fbd4a4487e9481af53a345c8d73777f227b42
* This is a verbatim copy taken at record time. Do not edit.
* tb_temp_accuracy_mc_postlayout -- GENERATED by sim/build_tb.py
* Do not edit. Sources:
*   sim/temp-accuracy-mc/testbench/stimulus.spice
*   layout/postlayout/temp_core.spice  (sha256 141d839b8dd157a79a73b70d05ffa0a0cb15d46adc8640d397bfae8023d0c9b6)
* Regenerate with:
*   python3 sim/build_tb.py

* temp-accuracy-mc -- stimulus half of the testbench fragment.
*
* The other half is a verbatim copy of design/netlist/temp_core.spice,
* appended by sim/build_tb.py to produce tb_temp_accuracy_mc.spice. Edit
* THIS file (or the schematic), never the generated fragment.
*
* Netlist FRAGMENT: no .include / .lib / .temp / .control / .end -- the
* harness owns those. Parameters supplied by sim/harness/montecarlo.py:
* vdd_val, vdd_nom, temp_c (plus .option seed=/.param sw_stat_mismatch=1,
* which are the whole point of this deck -- see that module's docstring).
*
* WHAT THIS EXPERIMENT SUBSTANTIATES (issue #15)
*
* spec/target-spec.md#temp-accuracy-untrimmed and #temp-accuracy-trimmed --
* the LOCAL MISMATCH share of both [3sigma] rows, complementing the
* deterministic corner-sweep systematic/corner share already published by
* sim/temp-accuracy-vt/ (#13) and sim/temp-core-designer-check/. Runs the
* SAME idealised-IBIAS cell-level DUT sim/temp-core-designer-check/ uses
* (design/temp_core.spice, 500 nA idealised IBIAS reference, not the
* assembled path's bias_core-driven current) -- deliberate, not a cut
* corner: mismatch is a property of THIS cell's own devices (the PNP
* pair/ratio, the R1/R2/RISO resistor ratios, the differential-pair
* amplifier), not of bias_core's startup dynamics, so isolating it on the
* cheaper idealised-bias cell-level testbench is the right level to run
* N=500-2000 independent ngspice invocations at, the way
* temp-core-designer-check already isolates the systematic term on the same
* cell. The assembled-path corner sweep (#13) remains the authority for the
* systematic/process/temperature/rail axis; this experiment adds the
* mismatch axis on top, at #13's own measured binding points.
*
* ONE BRANCH, NOT FIVE: temp-core-designer-check's other four branches
* (disabled-state draw, nominal-rail reference, 10 Mohm pad load, standalone
* trim ladder) answer questions this issue does not ask (Iq, supply
* sensitivity, buffering, trim-range) and would only add ngspice solve cost
* to N=500-2000 invocations per binding point for no evidence this issue
* needs.
*
* TWO TEMPERATURES, ONE DIE: #temp-accuracy-trimmed is not a direct
* measurement -- exactly as sim/temp-accuracy-vt/analyze_derived.py's module
* docstring explains, "error after a one-point 25 C gain trim" relates a
* point's own reading to that SAME corner's 25 C reading, and a real 25 C
* production trim calibrates each physical die against ITS OWN mismatch, not
* against a population average. So each MC sample here takes two readings
* off the SAME die (the same random mismatch draw): one at the fixed 25 C
* trim-reference point, one at this binding point's own temperature. `.temp`
* is a single global value per ngspice run, so this uses the
* `dc temp <T> <T> 1` idiom (a one-point DC sweep of the special TEMP
* variable) TWICE in the same control block -- ngspice has no interactive
* "settemp" command, and .param-elaborated mismatch values are fixed once at
* netlist load time regardless of how many analyses run afterward, so this
* changes the die's operating temperature WITHOUT re-drawing its mismatch
* (verified empirically -- see sim/tests/test_montecarlo.py). The 25 C
* reading's own `let`/`print` pair runs immediately after its `dc`, before
* the second `dc` switches ngspice's "current plot" out from under it (see
* sim/harness/montecarlo.py's `_format_analysis` docstring for why this
* can't just be two ordinary tb.json `measure` entries).
*
* Absolute-temperature probe `tk`: `temper` is not reachable from a measure
* expression, so it is published as a node voltage (1 V per kelvin), exactly
* as temp-core-designer-check does.

Btk tk 0 v='temper + 273.15'
Rtk tk 0 1G

vsup  vdd 0 dc {vdd_val}
ven   en  0 dc {vdd_val}
xdut  vdd 0 ibias en ptat ctat temp_core
ibref vdd ibias dc 500n
Rlp   ptat 0 1T
Rlc   ctat 0 1T

* temp_core -- post-layout netlist
* GENERATED by layout/postlayout.py -- do not edit.
*
* FROM THE LAYOUT: every device and its dimensions, the whole
*   topology, and first-order interconnect R/C on 69/73 nets
*   (sigma 1552.3 fF). klt 0.2.0, deck gf180mcu,
*   GDS sha256 360bbbea3f065932...
* Net names are the schematic's, restored through klt lvs's own net
*   correspondence -- match, 73/73 nets, every one paired.
*
* NOT FROM THE LAYOUT -- see layout/postlayout/AUDIT.md:
*   4 body/plate net(s) tied to the net the schematic puts
*   them on. The extraction deck's connectivity stack does not reach
*   an Nwell, a substrate ring, a bipolar base well or a MiM plate,
*   so they extract isolated and would otherwise float.
*   No ideal device: every golden device is drawn.
*
.subckt temp_core VDD VSS IBIAS EN PTAT CTAT

* --- drawn devices ---
X1 VSS VSS VSS VSS nfet_03v3 L=8u W=4u nf=1 ad=3.2p as=3.2p pd=9.6u ps=9.6u m=1
X2 N1 N1 VSS VSS nfet_03v3 L=8u W=4u nf=1 ad=3.2p as=3.2p pd=9.6u ps=9.6u m=1
X3 N2 N1 VSS VSS nfet_03v3 L=8u W=4u nf=1 ad=3.2p as=3.2p pd=9.6u ps=9.6u m=1
X4 N2 N1 VSS VSS nfet_03v3 L=8u W=4u nf=1 ad=3.2p as=3.2p pd=9.6u ps=9.6u m=1
X5 N1 N1 VSS VSS nfet_03v3 L=8u W=4u nf=1 ad=3.2p as=3.2p pd=9.6u ps=9.6u m=1
X6 VSS VSS VSS VSS nfet_03v3 L=8u W=4u nf=1 ad=3.2p as=3.2p pd=9.6u ps=9.6u m=1
X7 PG N2 VSS VSS nfet_03v3 L=8u W=8u nf=1 ad=6.4p as=6.4p pd=17.6u ps=17.6u m=1
X8 IBIAS NBG VSS VSS nfet_03v3 L=2u W=4u nf=1 ad=3.2p as=3.2p pd=9.6u ps=9.6u m=1
X9 IBIAS EN NBG VSS nfet_03v3 L=0.5u W=2u nf=1 ad=1.6p as=1.6p pd=5.6u ps=5.6u m=1
X10 NBG ENB VSS VSS nfet_03v3 L=0.5u W=2u nf=1 ad=1.6p as=1.6p pd=5.6u ps=5.6u m=1
X11 PB NBG VSS VSS nfet_03v3 L=2u W=4u nf=1 ad=3.2p as=3.2p pd=9.6u ps=9.6u m=1
X12 PCAS NBG VSS VSS nfet_03v3 L=2u W=4u nf=1 ad=3.2p as=3.2p pd=9.6u ps=9.6u m=1
X13 ENB EN VSS VSS nfet_03v3 L=0.5u W=1u nf=1 ad=0.8p as=0.8p pd=3.6u ps=3.6u m=1
X14 ND NR VSS VSS nfet_03v3 L=2u W=2u nf=1 ad=1.6p as=1.6p pd=5.6u ps=5.6u m=1
X15 PG ND VSS VSS nfet_03v3 L=1u W=4u nf=1 ad=3.2p as=3.2p pd=9.6u ps=9.6u m=1
X16 NR NR VSS VSS nfet_03v3 L=2u W=2u nf=1 ad=1.6p as=1.6p pd=5.6u ps=5.6u m=1
X17 ND ENB VSS VSS nfet_03v3 L=0.5u W=2u nf=1 ad=1.6p as=1.6p pd=5.6u ps=5.6u m=1
X18 PTAT ENB VSS VSS nfet_03v3 L=1u W=1u nf=1 ad=0.8p as=0.8p pd=3.6u ps=3.6u m=1
X19 CTAT ENB VSS VSS nfet_03v3 L=1u W=1u nf=1 ad=0.8p as=0.8p pd=3.6u ps=3.6u m=1
X20 N2 ENB VSS VSS nfet_03v3 L=1u W=2u nf=1 ad=1.6p as=1.6p pd=5.6u ps=5.6u m=1
X21 NT ENB VSS VSS nfet_03v3 L=1u W=2u nf=1 ad=1.6p as=1.6p pd=5.6u ps=5.6u m=1
X22 T5 VDD T4 VSS nfet_03v3 L=0.5u W=32u nf=1 ad=25.6p as=25.6p pd=65.6u ps=65.6u m=1
X23 T3 VSS T2 VSS nfet_03v3 L=0.5u W=32u nf=1 ad=25.6p as=25.6p pd=65.6u ps=65.6u m=1
X24 T1 VSS T0 VSS nfet_03v3 L=0.5u W=32u nf=1 ad=25.6p as=25.6p pd=65.6u ps=65.6u m=1
X25 T0 VSS VSS VSS nfet_03v3 L=0.5u W=32u nf=1 ad=25.6p as=25.6p pd=65.6u ps=65.6u m=1
X26 T2 VSS T1 VSS nfet_03v3 L=0.5u W=32u nf=1 ad=25.6p as=25.6p pd=65.6u ps=65.6u m=1
X27 T4 VSS T3 VSS nfet_03v3 L=0.5u W=32u nf=1 ad=25.6p as=25.6p pd=65.6u ps=65.6u m=1
X28 NT NT NT NT pfet_03v3 L=4u W=16u nf=1 ad=12.8p as=12.8p pd=33.6u ps=33.6u m=1
X29 N1 NA NT NT pfet_03v3 L=4u W=16u nf=1 ad=12.8p as=12.8p pd=33.6u ps=33.6u m=1
X30 N2 NB NT NT pfet_03v3 L=4u W=16u nf=1 ad=12.8p as=12.8p pd=33.6u ps=33.6u m=1
X31 N2 NB NT NT pfet_03v3 L=4u W=16u nf=1 ad=12.8p as=12.8p pd=33.6u ps=33.6u m=1
X32 N1 NA NT NT pfet_03v3 L=4u W=16u nf=1 ad=12.8p as=12.8p pd=33.6u ps=33.6u m=1
X33 NT NT NT NT pfet_03v3 L=4u W=16u nf=1 ad=12.8p as=12.8p pd=33.6u ps=33.6u m=1
X34 NT PB VDD VDD pfet_03v3 L=4u W=20u nf=1 ad=16p as=16p pd=41.6u ps=41.6u m=1
X35 VDD VDD VDD VDD pfet_03v3 L=4u W=4u nf=1 ad=3.2p as=3.2p pd=9.6u ps=9.6u m=1
X36 M1D PG VDD VDD pfet_03v3 L=4u W=4u nf=1 ad=3.2p as=3.2p pd=9.6u ps=9.6u m=1
X37 NA PCAS M1D VDD pfet_03v3 L=1u W=4u nf=1 ad=3.2p as=3.2p pd=9.6u ps=9.6u m=1
X38 M2D PG VDD VDD pfet_03v3 L=4u W=4u nf=1 ad=3.2p as=3.2p pd=9.6u ps=9.6u m=1
X39 NB PCAS M2D VDD pfet_03v3 L=1u W=4u nf=1 ad=3.2p as=3.2p pd=9.6u ps=9.6u m=1
X40 M3D PG VDD VDD pfet_03v3 L=4u W=4u nf=1 ad=3.2p as=3.2p pd=9.6u ps=9.6u m=1
X41 PTAT PCAS M3D VDD pfet_03v3 L=1u W=4u nf=1 ad=3.2p as=3.2p pd=9.6u ps=9.6u m=1
X42 PTAT PCAS M3D VDD pfet_03v3 L=1u W=4u nf=1 ad=3.2p as=3.2p pd=9.6u ps=9.6u m=1
X43 M3D PG VDD VDD pfet_03v3 L=4u W=4u nf=1 ad=3.2p as=3.2p pd=9.6u ps=9.6u m=1
X44 NB PCAS M2D VDD pfet_03v3 L=1u W=4u nf=1 ad=3.2p as=3.2p pd=9.6u ps=9.6u m=1
X45 M2D PG VDD VDD pfet_03v3 L=4u W=4u nf=1 ad=3.2p as=3.2p pd=9.6u ps=9.6u m=1
X46 NA PCAS M1D VDD pfet_03v3 L=1u W=4u nf=1 ad=3.2p as=3.2p pd=9.6u ps=9.6u m=1
X47 M1D PG VDD VDD pfet_03v3 L=4u W=4u nf=1 ad=3.2p as=3.2p pd=9.6u ps=9.6u m=1
X48 VDD VDD VDD VDD pfet_03v3 L=4u W=4u nf=1 ad=3.2p as=3.2p pd=9.6u ps=9.6u m=1
X49 PG PB VDD VDD pfet_03v3 L=4u W=10u nf=1 ad=8p as=8p pd=21.6u ps=21.6u m=1
X50 PB PB VDD VDD pfet_03v3 L=4u W=10u nf=1 ad=8p as=8p pd=21.6u ps=21.6u m=1
X51 PCAS PCAS VDD VDD pfet_03v3 L=8u W=1u nf=1 ad=0.8p as=0.8p pd=3.6u ps=3.6u m=1
X52 ENB EN VDD VDD pfet_03v3 L=0.5u W=2u nf=1 ad=1.6p as=1.6p pd=5.6u ps=5.6u m=1
X53 ND PB VDD VDD pfet_03v3 L=8u W=1u nf=1 ad=0.8p as=0.8p pd=3.6u ps=3.6u m=1
X54 NR PG VDD VDD pfet_03v3 L=4u W=1u nf=1 ad=0.8p as=0.8p pd=3.6u ps=3.6u m=1
X55 PG EN VDD VDD pfet_03v3 L=0.5u W=4u nf=1 ad=3.2p as=3.2p pd=9.6u ps=9.6u m=1
X56 VSS VSS NC pnp_10p00x10p00
X57 VSS VSS NC pnp_10p00x10p00
X58 VSS VSS NC pnp_10p00x10p00
X59 VSS VSS NC pnp_10p00x10p00
X60 VSS VSS NA pnp_10p00x10p00
X61 VSS VSS NC pnp_10p00x10p00
X62 VSS VSS NC pnp_10p00x10p00
X63 VSS VSS NC pnp_10p00x10p00
X64 VSS VSS NC pnp_10p00x10p00
X65 PG NZ cap_mim_2f0_m3m4_noshield c_width=12u c_length=12u
X66 NB XR1__1 VSS ppolyf_u r_width=2u r_length=59.735u
X67 NC XR1__1 VSS ppolyf_u r_width=2u r_length=59.735u
X68 NA XRISO__1 VSS ppolyf_u r_width=2u r_length=55.525u
X69 CTAT XRISO__1 VSS ppolyf_u r_width=2u r_length=55.525u
X70 NZ XRZ__1 VSS ppolyf_u r_width=2u r_length=100u
X71 XRZ__2 XRZ__1 VSS ppolyf_u r_width=2u r_length=100u
X72 XRZ__2 XRZ__3 VSS ppolyf_u r_width=2u r_length=100u
X73 XRZ__4 XRZ__3 VSS ppolyf_u r_width=2u r_length=100u
X74 XRZ__4 XRZ__5 VSS ppolyf_u r_width=2u r_length=100u
X75 XRZ__6 XRZ__5 VSS ppolyf_u r_width=2u r_length=100u
X76 XRZ__6 XRZ__7 VSS ppolyf_u r_width=2u r_length=100u
X77 XRZ__8 XRZ__7 VSS ppolyf_u r_width=2u r_length=100u
X78 XRZ__8 XRZ__9 VSS ppolyf_u r_width=2u r_length=100u
X79 N2 XRZ__9 VSS ppolyf_u r_width=2u r_length=100u
X80 PTAT XR2F__1 VSS ppolyf_u r_width=2u r_length=110.525u
X81 XR2F__2 XR2F__1 VSS ppolyf_u r_width=2u r_length=110.525u
X82 XR2F__2 XR2F__3 VSS ppolyf_u r_width=2u r_length=110.525u
X83 XR2F__4 XR2F__3 VSS ppolyf_u r_width=2u r_length=110.525u
X84 XR2F__4 XR2F__5 VSS ppolyf_u r_width=2u r_length=110.525u
X85 XR2F__6 XR2F__5 VSS ppolyf_u r_width=2u r_length=110.525u
X86 XR2F__6 XR2F__7 VSS ppolyf_u r_width=2u r_length=110.525u
X87 XR2F__8 XR2F__7 VSS ppolyf_u r_width=2u r_length=110.525u
X88 XR2F__8 XR2F__9 VSS ppolyf_u r_width=2u r_length=110.525u
X89 XR2F__10 XR2F__9 VSS ppolyf_u r_width=2u r_length=110.525u
X90 XR2F__10 XR2F__11 VSS ppolyf_u r_width=2u r_length=110.525u
X91 XR2F__12 XR2F__11 VSS ppolyf_u r_width=2u r_length=110.525u
X92 XR2F__12 XR2F__13 VSS ppolyf_u r_width=2u r_length=110.525u
X93 XR2F__14 XR2F__13 VSS ppolyf_u r_width=2u r_length=110.525u
X94 XR2F__14 XR2F__15 VSS ppolyf_u r_width=2u r_length=110.525u
X95 XR2F__16 XR2F__15 VSS ppolyf_u r_width=2u r_length=110.525u
X96 XR2F__16 XR2F__17 VSS ppolyf_u r_width=2u r_length=110.525u
X97 XR2F__18 XR2F__17 VSS ppolyf_u r_width=2u r_length=110.525u
X98 XR2F__18 XR2F__19 VSS ppolyf_u r_width=2u r_length=110.525u
X99 XR2F__20 XR2F__19 VSS ppolyf_u r_width=2u r_length=110.525u
X100 XR2F__20 XR2F__21 VSS ppolyf_u r_width=2u r_length=110.525u
X101 XR2F__22 XR2F__21 VSS ppolyf_u r_width=2u r_length=110.525u
X102 XR2F__22 XR2F__23 VSS ppolyf_u r_width=2u r_length=110.525u
X103 T5 XR2F__23 VSS ppolyf_u r_width=2u r_length=110.525u
X104 T5 XR2T5__1 VSS ppolyf_u r_width=2u r_length=114.855u
X105 T4 XR2T5__1 VSS ppolyf_u r_width=2u r_length=114.855u
X106 T4 XR2T4__1 VSS ppolyf_u r_width=2u r_length=57.345u
X107 T3 XR2T4__1 VSS ppolyf_u r_width=2u r_length=57.345u
X108 T3 XR2T3__1 VSS ppolyf_u r_width=2u r_length=28.59u
X109 T2 XR2T3__1 VSS ppolyf_u r_width=2u r_length=28.59u
X110 T2 XR2T2__1 VSS ppolyf_u r_width=2u r_length=14.21u
X111 T1 XR2T2__1 VSS ppolyf_u r_width=2u r_length=14.21u
X112 T1 XR2T1__1 VSS ppolyf_u r_width=2u r_length=7.015u
X113 T0 XR2T1__1 VSS ppolyf_u r_width=2u r_length=7.015u
X114 T0 XR2T0__1 VSS ppolyf_u r_width=2u r_length=3.425u
X115 VSS XR2T0__1 VSS ppolyf_u r_width=2u r_length=3.425u

R_30 XRZ__2 XRZ__2__par 50.5749
C_30 XRZ__2__par VSS 1.599507e-15
R_31 XRZ__4 XRZ__4__par 50.5749
C_31 XRZ__4__par VSS 1.599507e-15
R_32 XRZ__6 XRZ__6__par 50.5749
C_32 XRZ__6__par VSS 1.599507e-15
R_33 XRZ__8 XRZ__8__par 50.5749
C_33 XRZ__8__par VSS 1.599507e-15
R_34 XR2F__2 XR2F__2__par 50.5749
C_34 XR2F__2__par VSS 1.599507e-15
R_35 XR2F__4 XR2F__4__par 50.5749
C_35 XR2F__4__par VSS 1.599507e-15
R_36 XR2F__6 XR2F__6__par 50.5749
C_36 XR2F__6__par VSS 1.599507e-15
R_37 XR2F__8 XR2F__8__par 50.5749
C_37 XR2F__8__par VSS 1.599507e-15
R_38 XR2F__10 XR2F__10__par 50.5749
C_38 XR2F__10__par VSS 1.599507e-15
R_39 XR2F__12 XR2F__12__par 50.5749
C_39 XR2F__12__par VSS 1.599507e-15
R_40 XR2F__14 XR2F__14__par 50.5749
C_40 XR2F__14__par VSS 1.599507e-15
R_41 XR2F__16 XR2F__16__par 50.5749
C_41 XR2F__16__par VSS 1.599507e-15
R_42 XR2F__18 XR2F__18__par 50.5749
C_42 XR2F__18__par VSS 1.599507e-15
R_43 XR2F__20 XR2F__20__par 50.5749
C_43 XR2F__20__par VSS 1.599507e-15
R_44 XR2F__22 XR2F__22__par 50.5749
C_44 XR2F__22__par VSS 1.599507e-15
R_50 XR2T0__1 XR2T0__1__par 50.5749
C_50 XR2T0__1__par VSS 1.599507e-15
R_51 XR2T1__1 XR2T1__1__par 50.5749
C_51 XR2T1__1__par VSS 1.599507e-15
R_56 XR2T2__1 XR2T2__1__par 50.5749
C_56 XR2T2__1__par VSS 1.599507e-15
R_60 XR2T3__1 XR2T3__1__par 50.5749
C_60 XR2T3__1__par VSS 1.599507e-15
R_68 XRISO__1 XRISO__1__par 50.5749
C_68 XRISO__1__par VSS 1.599507e-15
R_69 XR2T4__1 XR2T4__1__par 50.5749
C_69 XR2T4__1__par VSS 1.599507e-15
R_70 XR1__1 XR1__1__par 50.5749
C_70 XR1__1__par VSS 1.599507e-15
R_71 XRZ__1 XRZ__1__par 50.5749
C_71 XRZ__1__par VSS 1.599507e-15
R_72 XRZ__3 XRZ__3__par 50.5749
C_72 XRZ__3__par VSS 1.599507e-15
R_73 XRZ__5 XRZ__5__par 50.5749
C_73 XRZ__5__par VSS 1.599507e-15
R_74 XRZ__7 XRZ__7__par 50.5749
C_74 XRZ__7__par VSS 1.599507e-15
R_75 XRZ__9 XRZ__9__par 50.5749
C_75 XRZ__9__par VSS 1.599507e-15
R_76 XR2F__1 XR2F__1__par 50.5749
C_76 XR2F__1__par VSS 1.599507e-15
R_77 XR2F__3 XR2F__3__par 50.5749
C_77 XR2F__3__par VSS 1.599507e-15
R_78 XR2F__5 XR2F__5__par 50.5749
C_78 XR2F__5__par VSS 1.599507e-15
R_79 XR2F__7 XR2F__7__par 50.5749
C_79 XR2F__7__par VSS 1.599507e-15
R_80 XR2F__9 XR2F__9__par 50.5749
C_80 XR2F__9__par VSS 1.599507e-15
R_81 XR2F__11 XR2F__11__par 50.5749
C_81 XR2F__11__par VSS 1.599507e-15
R_82 XR2F__13 XR2F__13__par 50.5749
C_82 XR2F__13__par VSS 1.599507e-15
R_83 XR2F__15 XR2F__15__par 50.5749
C_83 XR2F__15__par VSS 1.599507e-15
R_84 XR2F__17 XR2F__17__par 50.5749
C_84 XR2F__17__par VSS 1.599507e-15
R_85 XR2F__19 XR2F__19__par 50.5749
C_85 XR2F__19__par VSS 1.599507e-15
R_86 XR2F__21 XR2F__21__par 50.5749
C_86 XR2F__21__par VSS 1.599507e-15
R_87 XR2F__23 XR2F__23__par 50.5749
C_87 XR2F__23__par VSS 1.599507e-15
R_88 XR2T5__1 XR2T5__1__par 50.5749
C_88 XR2T5__1__par VSS 1.599507e-15
RCTAT CTAT CTAT__par 508.901
CCTAT CTAT__par VSS 3.2409351e-14
REN EN EN__par 1473.1873
CEN EN__par VSS 3.3733752e-14
RENB ENB ENB__par 1722.3174
CENB ENB__par VSS 3.6434644e-14
RIBIAS IBIAS IBIAS__par 322.6504
CIBIAS IBIAS__par VSS 2.0287657e-14
RM1D M1D M1D__par 1326.5002
CM1D M1D__par VSS 2.6584926e-14
RM2D M2D M2D__par 1250.9542
CM2D M2D__par VSS 2.5194004e-14
RM3D M3D M3D__par 1175.4138
CM3D M3D__par VSS 2.3803081e-14
RN1 N1 N1__par 3916.0744
CN1 N1__par VSS 3.9166451e-14
RN2 N2 N2__par 2349.712
CN2 N2__par VSS 5.2203575e-14
RNA NA NA__par 2133.218
CNA NA__par VSS 6.3089263e-14
RNB NB NB__par 2057.3709
CNB NB__par VSS 4.3487422e-14
RNBG NBG NBG__par 1144.9314
CNBG NBG__par VSS 2.6946068e-14
RNC NC NC__par 65.9407
CNC NC__par VSS 8.5417204e-14
RND ND ND__par 1512.6715
CND ND__par VSS 3.4769335e-14
RNR NR NR__par 1694.9168
CNR NR__par VSS 3.5399052e-14
RNT NT NT__par 5451.5605
CNT NT__par VSS 7.8898189e-14
RNZ NZ NZ__par 105.4766
CNZ NZ__par VSS 2.9335487e-14
RPB PB PB__par 3535.6753
CPB PB__par VSS 4.7145745e-14
RPCAS PCAS PCAS__par 4548.8647
CPCAS PCAS__par VSS 5.3738496e-14
RPG PG PG__par 5100.563
CPG PG__par VSS 6.1728862e-14
RPTAT PTAT PTAT__par 962.4337
CPTAT PTAT__par VSS 3.9542032e-14
RT0 T0 T0__par 1253.0071
CT0 T0__par VSS 5.5998739e-14
RT1 T1 T1__par 1214.9021
CT1 T1__par VSS 5.5179431e-14
RT2 T2 T2__par 1176.8024
CT2 T2__par VSS 5.4360123e-14
RT3 T3 T3__par 1138.7083
CT3 T3__par VSS 5.3540815e-14
RT4 T4 T4__par 1100.6204
CT4 T4__par VSS 5.2721507e-14
RT5 T5 T5__par 607.3914
CT5 T5__par VSS 4.5515196e-14
RVDD VDD VDD__par 11776.8157
CVDD VDD__par VSS 1.23638547e-13
RVSS VSS VSS__par 3083.8865
CVSS VSS__par VSS 1.58058319e-13
.ends temp_core
