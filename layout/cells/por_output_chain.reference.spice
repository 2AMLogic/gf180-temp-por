* por_output_chain -- klt lvs reference netlist
* generated by layout/lvs_reference.py from design/netlist/por_output_chain.spice
* Do not edit: edit the schematic, re-run design/netlist.py, re-run this.
.SUBCKT por_output_chain IBIAS POR_RAW RESETn VDD VSS vsubs
M1 IBIAS IBIAS VSS vsubs nfet L=4U W=4U
M2 PDN PDN VDD NW1 pfet L=10U W=2U
M3 PDN IBIAS VSS vsubs nfet L=25U W=0.5U
M4 NDL NDL VSS vsubs nfet L=10U W=2U
M5 NDGN NDL VSS vsubs nfet L=10U W=10U
M6 NDG POR_RAW NDGN vsubs nfet L=0.5U W=1U
M7 PGDG NDG VSS vsubs nfet L=0.5U W=2U
M8 PGDGB PGDG VSS vsubs nfet L=2U W=0.5U
M9 TIM PGDGB VSS vsubs nfet L=1U W=1U
M10 ND1 NDL VSS vsubs nfet L=10U W=0.5U
M11 TRIP ND1 VSS vsubs nfet L=1U W=1U
M12 ND1 RESETn VSS vsubs nfet L=1U W=1U
M13 RSTB TRIP NNAND vsubs nfet L=0.5U W=2U
M14 NNAND PGDG VSS vsubs nfet L=0.5U W=2U
M15 RESETn RSTB VSS vsubs nfet L=0.5U W=10U
M16 NDL PDN VDD NW1 pfet L=10U W=2U
M17 NDGP PDN VDD NW1 pfet L=10U W=10U
M18 NTS PDN VDD NW1 pfet L=10U W=0.5U
M19 TRIP PDN VDD NW1 pfet L=10U W=0.5U
M20 NDG POR_RAW NDGP NW1 pfet L=0.5U W=1U
M21 PGDG NDG VDD NW1 pfet L=2U W=0.5U
M22 PGDGB PGDG VDD NW1 pfet L=0.5U W=2U
M23 TIM PGDGB NTS NW1 pfet L=1U W=2U
M24 ND1 TIM VDD NW1 pfet L=1U W=2U
M25 RSTB TRIP VDD NW1 pfet L=0.5U W=4U
M26 RSTB PGDG VDD NW1 pfet L=0.5U W=4U
M27 RSTB RESETn VDD NW1 pfet L=10U W=0.5U
M28 RESETn RSTB VDD NW1 pfet L=1U W=1U
C29 XCDG.NDG XCDG.VSS 2.42e-13 cap_mim_2f0_m4m5_noshield
C30 XCTIM.1.TIM XCTIM.1.VSS 1.568e-12 cap_mim_2f0_m4m5_noshield
C31 XCTIM.2.TIM XCTIM.2.VSS 1.568e-12 cap_mim_2f0_m4m5_noshield
C32 XCTIM.3.TIM XCTIM.3.VSS 1.568e-12 cap_mim_2f0_m4m5_noshield
C33 XCTIM.4.TIM XCTIM.4.VSS 1.568e-12 cap_mim_2f0_m4m5_noshield
.ENDS por_output_chain
