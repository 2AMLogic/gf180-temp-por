* extracted by klt extract --deck gf180mcu

* cell por_output_chain
* pin IBIAS
* pin POR_RAW
* pin RESETn
* pin VDD
* pin VSS
* pin vsubs
.SUBCKT por_output_chain IBIAS POR_RAW RESETn VDD VSS vsubs
* device instance $1 r0 *1 19.9,0.25 nfet
M$1 \$6 IBIAS VSS vsubs nfet L=25U W=0.5U AS=0.4P AD=0.4P PS=2.6U PD=2.6U
* device instance $2 r0 *1 67.4,0.25 nfet
M$2 \$10 \$9 VSS vsubs nfet L=2U W=0.5U AS=0.4P AD=0.4P PS=2.6U PD=2.6U
* device instance $3 r0 *1 79.6,0.25 nfet
M$3 \$12 \$2 VSS vsubs nfet L=10U W=0.5U AS=0.4P AD=0.4P PS=2.6U PD=2.6U
* device instance $4 r0 *1 60.45,0.5 nfet
M$4 \$8 POR_RAW \$7 vsubs nfet L=0.5U W=1U AS=0.8P AD=0.8P PS=3.6U PD=3.6U
* device instance $5 r0 *1 71.5,0.5 nfet
M$5 \$11 \$10 VSS vsubs nfet L=1U W=1U AS=0.8P AD=0.8P PS=3.6U PD=3.6U
* device instance $6 r0 *1 87.7,0.5 nfet
M$6 \$13 \$12 VSS vsubs nfet L=1U W=1U AS=0.8P AD=0.8P PS=3.6U PD=3.6U
* device instance $7 r0 *1 91.3,0.5 nfet
M$7 \$12 RESETn VSS vsubs nfet L=1U W=1U AS=0.8P AD=0.8P PS=3.6U PD=3.6U
* device instance $8 r0 *1 40,1 nfet
M$8 \$2 \$2 VSS vsubs nfet L=10U W=2U AS=1.6P AD=1.6P PS=5.6U PD=5.6U
* device instance $9 r0 *1 63.55,1 nfet
M$9 \$9 \$8 VSS vsubs nfet L=0.5U W=2U AS=1.6P AD=1.6P PS=5.6U PD=5.6U
* device instance $10 r0 *1 94.65,1 nfet
M$10 \$17 \$13 \$14 vsubs nfet L=0.5U W=2U AS=1.6P AD=1.6P PS=5.6U PD=5.6U
* device instance $11 r0 *1 97.75,1 nfet
M$11 \$14 \$9 VSS vsubs nfet L=0.5U W=2U AS=1.6P AD=1.6P PS=5.6U PD=5.6U
* device instance $12 r0 *1 2.8,2 nfet
M$12 IBIAS IBIAS VSS vsubs nfet L=4U W=4U AS=3.2P AD=3.2P PS=9.6U PD=9.6U
* device instance $13 r0 *1 52.6,5 nfet
M$13 \$7 \$2 VSS vsubs nfet L=10U W=10U AS=8P AD=8P PS=21.6U PD=21.6U
* device instance $14 r0 *1 212.25,5 nfet
M$14 RESETn \$17 VSS vsubs nfet L=0.5U W=10U AS=8P AD=8P PS=21.6U PD=21.6U
* device instance $15 r0 *1 147.4,0.25 pfet
M$15 \$16 \$6 VDD \$19 pfet L=10U W=0.5U AS=0.4P AD=0.4P PS=2.6U PD=2.6U
* device instance $16 r0 *1 160,0.25 pfet
M$16 \$13 \$6 VDD \$19 pfet L=10U W=0.5U AS=0.4P AD=0.4P PS=2.6U PD=2.6U
* device instance $17 r0 *1 171.7,0.25 pfet
M$17 \$9 \$8 VDD \$19 pfet L=2U W=0.5U AS=0.4P AD=0.4P PS=2.6U PD=2.6U
* device instance $18 r0 *1 196.8,0.25 pfet
M$18 \$17 RESETn VDD \$19 pfet L=10U W=0.5U AS=0.4P AD=0.4P PS=2.6U PD=2.6U
* device instance $19 r0 *1 167.85,0.5 pfet
M$19 \$8 POR_RAW \$15 \$19 pfet L=0.5U W=1U AS=0.8P AD=0.8P PS=3.6U PD=3.6U
* device instance $20 r0 *1 204.9,0.5 pfet
M$20 RESETn \$17 VDD \$19 pfet L=1U W=1U AS=0.8P AD=0.8P PS=3.6U PD=3.6U
* device instance $21 r0 *1 109.6,1 pfet
M$21 \$6 \$6 VDD \$19 pfet L=10U W=2U AS=1.6P AD=1.6P PS=5.6U PD=5.6U
* device instance $22 r0 *1 122.2,1 pfet
M$22 \$2 \$6 VDD \$19 pfet L=10U W=2U AS=1.6P AD=1.6P PS=5.6U PD=5.6U
* device instance $23 r0 *1 175.55,1 pfet
M$23 \$10 \$9 VDD \$19 pfet L=0.5U W=2U AS=1.6P AD=1.6P PS=5.6U PD=5.6U
* device instance $24 r0 *1 178.9,1 pfet
M$24 \$11 \$10 \$16 \$19 pfet L=1U W=2U AS=1.6P AD=1.6P PS=5.6U PD=5.6U
* device instance $25 r0 *1 182.5,1 pfet
M$25 \$12 \$11 VDD \$19 pfet L=1U W=2U AS=1.6P AD=1.6P PS=5.6U PD=5.6U
* device instance $26 r0 *1 185.85,2 pfet
M$26 \$17 \$13 VDD \$19 pfet L=0.5U W=4U AS=3.2P AD=3.2P PS=9.6U PD=9.6U
* device instance $27 r0 *1 188.95,2 pfet
M$27 \$17 \$9 VDD \$19 pfet L=0.5U W=4U AS=3.2P AD=3.2P PS=9.6U PD=9.6U
* device instance $28 r0 *1 134.8,5 pfet
M$28 \$15 \$6 VDD \$19 pfet L=10U W=10U AS=8P AD=8P PS=21.6U PD=21.6U
* device instance $29 r0 *1 68.8,37.7 cap_mim_2f0_m4m5_noshield
C$29 \$22 \$23 2.42e-13 cap_mim_2f0_m4m5_noshield
* device instance $30 r0 *1 15.7,46.2 cap_mim_2f0_m4m5_noshield
C$30 \$20 \$26 1.568e-12 cap_mim_2f0_m4m5_noshield
* device instance $31 r0 *1 46.5,46.2 cap_mim_2f0_m4m5_noshield
C$31 \$21 \$27 1.568e-12 cap_mim_2f0_m4m5_noshield
* device instance $32 r0 *1 15.7,77 cap_mim_2f0_m4m5_noshield
C$32 \$24 \$28 1.568e-12 cap_mim_2f0_m4m5_noshield
* device instance $33 r0 *1 46.5,77 cap_mim_2f0_m4m5_noshield
C$33 \$25 \$29 1.568e-12 cap_mim_2f0_m4m5_noshield
* device instance _10 r0 *1 0,0
R_10 \$10 \$10__par 4066.8737
* device instance _10 r0 *1 0,0
C_10 \$10__par vsubs 3.8945287e-14
* device instance _11 r0 *1 0,0
R_11 \$11 \$11__par 4003.4777
* device instance _11 r0 *1 0,0
C_11 \$11__par vsubs 3.7210339e-14
* device instance _12 r0 *1 0,0
R_12 \$12 \$12__par 4009.3517
* device instance _12 r0 *1 0,0
C_12 \$12__par vsubs 3.9540693e-14
* device instance _13 r0 *1 0,0
R_13 \$13 \$13__par 4060.1906
* device instance _13 r0 *1 0,0
C_13 \$13__par vsubs 3.9480796e-14
* device instance _14 r0 *1 0,0
R_14 \$14 \$14__par 3939.9598
* device instance _14 r0 *1 0,0
C_14 \$14__par vsubs 3.5425418e-14
* device instance _15 r0 *1 0,0
R_15 \$15 \$15__par 3936.7209
* device instance _15 r0 *1 0,0
C_15 \$15__par vsubs 3.4117005e-14
* device instance _16 r0 *1 0,0
R_16 \$16 \$16__par 3938.5314
* device instance _16 r0 *1 0,0
C_16 \$16__par vsubs 3.4848444e-14
* device instance _17 r0 *1 0,0
R_17 \$17 \$17__par 4076.1772
* device instance _17 r0 *1 0,0
C_17 \$17__par vsubs 4.4255369e-14
* device instance _2 r0 *1 0,0
R_2 \$2 \$2__par 4462.4943
* device instance _2 r0 *1 0,0
C_2 \$2__par vsubs 4.7374149e-14
* device instance _6 r0 *1 0,0
R_6 \$6 \$6__par 4872.4842
* device instance _6 r0 *1 0,0
C_6 \$6__par vsubs 5.6528747e-14
* device instance _7 r0 *1 0,0
R_7 \$7 \$7__par 3937.0807
* device instance _7 r0 *1 0,0
C_7 \$7__par vsubs 3.4262384e-14
* device instance _8 r0 *1 0,0
R_8 \$8 \$8__par 4070.1194
* device instance _8 r0 *1 0,0
C_8 \$8__par vsubs 3.8582127e-14
* device instance _9 r0 *1 0,0
R_9 \$9 \$9__par 4189.4235
* device instance _9 r0 *1 0,0
C_9 \$9__par vsubs 4.2346747e-14
* device instance IBIAS r0 *1 0,0
RIBIAS IBIAS IBIAS__par 4398.6611
* device instance IBIAS r0 *1 0,0
CIBIAS IBIAS__par vsubs 4.5280553e-14
* device instance POR_RAW r0 *1 0,0
RPOR_RAW POR_RAW POR_RAW__par 4047.2842
* device instance POR_RAW r0 *1 0,0
CPOR_RAW POR_RAW__par vsubs 3.435215e-14
* device instance RESETn r0 *1 0,0
RRESETn RESETn RESETn__par 4167.0798
* device instance RESETn r0 *1 0,0
CRESETn RESETn__par vsubs 4.4306787e-14
* device instance VDD r0 *1 0,0
RVDD VDD VDD__par 79.793
* device instance VDD r0 *1 0,0
CVDD VDD__par vsubs 6.9019152e-14
* device instance VSS r0 *1 0,0
RVSS VSS VSS__par 66.6796
* device instance VSS r0 *1 0,0
CVSS VSS__par vsubs 1.12713456e-13
.ENDS por_output_chain
