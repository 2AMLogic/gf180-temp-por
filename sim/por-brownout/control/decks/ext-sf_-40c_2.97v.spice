* por-brownout recovery-edge control @ sf / -40.0 C / 2.97 V -- GENERATED by run_recovery_reassert.py, do not edit
* DUT fragment: sim/por-brownout/testbench-postlayout/tb_por_brownout_postlayout.spice
* pdk=gf180mcuD@c6d73a35f524070e85faff4a6a9eef49553ebc2b  harness=0.1.0

.param vdd_nom=3.3
.param vdd_val=2.97
.param temp_c=-40.0

.include "/home/ubuntu/.volare/gf180mcuD/libs.tech/ngspice/design.ngspice"
.lib "/home/ubuntu/.volare/gf180mcuD/libs.tech/ngspice/sm141064.ngspice" sf
.lib "/home/ubuntu/.volare/gf180mcuD/libs.tech/ngspice/sm141064.ngspice" res_typical
.lib "/home/ubuntu/.volare/gf180mcuD/libs.tech/ngspice/sm141064.ngspice" bjt_typical
.lib "/home/ubuntu/.volare/gf180mcuD/libs.tech/ngspice/sm141064.ngspice" diode_typical
.lib "/home/ubuntu/.volare/gf180mcuD/libs.tech/ngspice/sm141064.ngspice" moscap_typical
.lib "/home/ubuntu/.volare/gf180mcuD/libs.tech/ngspice/sm141064.ngspice" mimcap_typical

.temp -40.0
.options reltol=1e-4
.options abstol=1e-13
.options vntol=1e-8
.options method=gear

.include "../../testbench-postlayout/tb_por_brownout_postlayout.spice"

.control
set numdgt=8
set noaskquit
tran 20u 55m
let praw_r = v(xdut.por_raw)/(v(vdd)+0.001)
let rst_r = v(resetn)/(v(vdd)+0.001)
let bok_r = v(xdut.bias_ok)/(v(vdd)+0.001)
meas tran treassert when v(resetn)=0.3 fall=1 td=20m
meas tran rst_r_min min rst_r from=20m to=55m
meas tran praw_r_min_dip min praw_r from=20m to=20.052m
meas tran praw_r_min_rec min praw_r from=20.052m to=21m
meas tran t_praw when praw_r=0.5 fall=1 td=20m
meas tran praw_w trig praw_r val=0.5 fall=1 td=20m targ praw_r val=0.5 rise=1 td=20m
meas tran bok_r_min_dip min bok_r from=20m to=20.052m
meas tran bok_r_min_rec min bok_r from=20.052m to=21m
meas tran t_rst when rst_r=0.1 fall=1 td=20m
meas tran rst_min min v(resetn) from=20m to=55m
meas tran rst_final find v(resetn) at=54.5m
.endc
.end
