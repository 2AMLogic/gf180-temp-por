* temp_core -- COMPOSITE post-layout netlist
* generated by layout/composite_netlist.py -- do not edit.
*
* WHAT THIS IS
*   MOS devices and interconnect parasitics taken from the LAYOUT
*     layout/reports/temp_core/extracted-parasitics.spice
*     (klt extract --deck gf180mcu --parasitics), plus every non-MOS
*     device taken VERBATIM from the golden schematic export
*     design/netlist/temp_core.spice.
*
* WHAT THIS IS NOT
*   It is NOT a parasitic-extracted analog core. The vertical PNPs,
*   poly resistors and MiM caps below are IDEAL SCHEMATIC DEVICES:
*   they are not drawn in the layout at all, so they carry no
*   extracted geometry, no parasitic R/C, and no layout-derived
*   matching. Any claim recorded against this netlist must say so in
*   the record's Claim field -- what it substantiates is real
*   interconnect parasitics loading the real MOS topology, and
*   nothing more. See layout/composite/AUDIT.md.
*
*   Device bodies are the other place this netlist takes connectivity
*   from the schematic: the curated deck draws no tap or well-label
*   layer, so an extracted body lands on a global substrate net or an
*   anonymous well net. Those are restored to the schematic's own
*   body nodes here, because a floating body cannot be simulated.
*
.subckt temp_core VDD VSS IBIAS EN PTAT CTAT

* ---- MOS devices: extracted from the layout ----
* device instance $1 r0 *1 49.5,-2 nfet
XM__1 VSS VSS VSS VSS nfet_03v3 L=8u W=4u nf=1 ad=3.2p as=3.2p pd=9.6u ps=9.6u m=1
* device instance $2 r0 *1 59.6,-2 nfet
XM__2 N1 N1 VSS VSS nfet_03v3 L=8u W=4u nf=1 ad=3.2p as=3.2p pd=9.6u ps=9.6u m=1
* device instance $3 r0 *1 69.7,-2 nfet
XM__3 N2 N1 VSS VSS nfet_03v3 L=8u W=4u nf=1 ad=3.2p as=3.2p pd=9.6u ps=9.6u m=1
* device instance $4 r0 *1 79.8,-2 nfet
XM__4 N2 N1 VSS VSS nfet_03v3 L=8u W=4u nf=1 ad=3.2p as=3.2p pd=9.6u ps=9.6u m=1
* device instance $5 r0 *1 89.9,-2 nfet
XM__5 N1 N1 VSS VSS nfet_03v3 L=8u W=4u nf=1 ad=3.2p as=3.2p pd=9.6u ps=9.6u m=1
* device instance $6 r0 *1 100,-2 nfet
XM__6 VSS VSS VSS VSS nfet_03v3 L=8u W=4u nf=1 ad=3.2p as=3.2p pd=9.6u ps=9.6u m=1
* device instance $7 r0 *1 177.5,-4 nfet
XM__7 PG N2 VSS VSS nfet_03v3 L=8u W=8u nf=1 ad=6.4p as=6.4p pd=17.6u ps=17.6u m=1
* device instance $8 r0 *1 190.7,-2 nfet
XM__8 IBIAS NBG VSS VSS nfet_03v3 L=2u W=4u nf=1 ad=3.2p as=3.2p pd=9.6u ps=9.6u m=1
* device instance $9 r0 *1 194.05,-1 nfet
XM__9 IBIAS EN NBG VSS nfet_03v3 L=0.5u W=2u nf=1 ad=1.6p as=1.6p pd=5.6u ps=5.6u m=1
* device instance $10 r0 *1 196.65,-1 nfet
XM__10 NBG ENB VSS VSS nfet_03v3 L=0.5u W=2u nf=1 ad=1.6p as=1.6p pd=5.6u ps=5.6u m=1
* device instance $11 r0 *1 200,-2 nfet
XM__11 PB NBG VSS VSS nfet_03v3 L=2u W=4u nf=1 ad=3.2p as=3.2p pd=9.6u ps=9.6u m=1
* device instance $12 r0 *1 210.2,-2 nfet
XM__12 PCAS NBG VSS VSS nfet_03v3 L=2u W=4u nf=1 ad=3.2p as=3.2p pd=9.6u ps=9.6u m=1
* device instance $13 r0 *1 226.25,-0.5 nfet
XM__13 ENB EN VSS VSS nfet_03v3 L=0.5u W=1u nf=1 ad=0.8p as=0.8p pd=3.6u ps=3.6u m=1
* device instance $14 r0 *1 239.7,-1 nfet
XM__14 ND NR VSS VSS nfet_03v3 L=2u W=2u nf=1 ad=1.6p as=1.6p pd=5.6u ps=5.6u m=1
* device instance $15 r0 *1 243.3,-2 nfet
XM__15 PG ND VSS VSS nfet_03v3 L=1u W=4u nf=1 ad=3.2p as=3.2p pd=9.6u ps=9.6u m=1
* device instance $16 r0 *1 253,-1 nfet
XM__16 NR NR VSS VSS nfet_03v3 L=2u W=2u nf=1 ad=1.6p as=1.6p pd=5.6u ps=5.6u m=1
* device instance $17 r0 *1 256.35,-1 nfet
XM__17 ND ENB VSS VSS nfet_03v3 L=0.5u W=2u nf=1 ad=1.6p as=1.6p pd=5.6u ps=5.6u m=1
* device instance $18 r0 *1 261.8,-0.5 nfet
XM__18 PTAT ENB VSS VSS nfet_03v3 L=1u W=1u nf=1 ad=0.8p as=0.8p pd=3.6u ps=3.6u m=1
* device instance $19 r0 *1 264.9,-0.5 nfet
XM__19 CTAT ENB VSS VSS nfet_03v3 L=1u W=1u nf=1 ad=0.8p as=0.8p pd=3.6u ps=3.6u m=1
* device instance $20 r0 *1 268,-1 nfet
XM__20 N2 ENB VSS VSS nfet_03v3 L=1u W=2u nf=1 ad=1.6p as=1.6p pd=5.6u ps=5.6u m=1
* device instance $21 r0 *1 271.1,-1 nfet
XM__21 NT ENB VSS VSS nfet_03v3 L=1u W=2u nf=1 ad=1.6p as=1.6p pd=5.6u ps=5.6u m=1
* device instance $22 r0 *1 273.95,-16 nfet
XM__22 T5 VDD T4 VSS nfet_03v3 L=0.5u W=32u nf=1 ad=25.6p as=25.6p pd=65.6u ps=65.6u m=1
* device instance $23 r0 *1 276.55,-16 nfet
XM__23 T3 VSS T2 VSS nfet_03v3 L=0.5u W=32u nf=1 ad=25.6p as=25.6p pd=65.6u ps=65.6u m=1
* device instance $24 r0 *1 279.15,-16 nfet
XM__24 T1 VSS T0 VSS nfet_03v3 L=0.5u W=32u nf=1 ad=25.6p as=25.6p pd=65.6u ps=65.6u m=1
* device instance $25 r0 *1 281.75,-16 nfet
XM__25 T0 VSS VSS VSS nfet_03v3 L=0.5u W=32u nf=1 ad=25.6p as=25.6p pd=65.6u ps=65.6u m=1
* device instance $26 r0 *1 284.35,-16 nfet
XM__26 T2 VSS T1 VSS nfet_03v3 L=0.5u W=32u nf=1 ad=25.6p as=25.6p pd=65.6u ps=65.6u m=1
* device instance $27 r0 *1 286.95,-16 nfet
XM__27 T4 VSS T3 VSS nfet_03v3 L=0.5u W=32u nf=1 ad=25.6p as=25.6p pd=65.6u ps=65.6u m=1
* device instance $28 r0 *1 217.3,32.5 pfet
XM__28 PCAS PCAS VDD VDD pfet_03v3 L=8u W=1u nf=1 ad=0.8p as=0.8p pd=3.6u ps=3.6u m=1
* device instance $29 r0 *1 232.6,32.5 pfet
XM__29 ND PB VDD VDD pfet_03v3 L=8u W=1u nf=1 ad=0.8p as=0.8p pd=3.6u ps=3.6u m=1
* device instance $30 r0 *1 247.9,32.5 pfet
XM__30 NR PG VDD VDD pfet_03v3 L=4u W=1u nf=1 ad=0.8p as=0.8p pd=3.6u ps=3.6u m=1
* device instance $31 r0 *1 223.65,33 pfet
XM__31 ENB EN VDD VDD pfet_03v3 L=0.5u W=2u nf=1 ad=1.6p as=1.6p pd=5.6u ps=5.6u m=1
* device instance $32 r0 *1 108.1,34 pfet
XM__32 VDD VDD VDD VDD pfet_03v3 L=4u W=4u nf=1 ad=3.2p as=3.2p pd=9.6u ps=9.6u m=1
* device instance $33 r0 *1 114.2,34 pfet
XM__33 M1D PG VDD VDD pfet_03v3 L=4u W=4u nf=1 ad=3.2p as=3.2p pd=9.6u ps=9.6u m=1
* device instance $34 r0 *1 118.8,34 pfet
XM__34 NA PCAS M1D VDD pfet_03v3 L=1u W=4u nf=1 ad=3.2p as=3.2p pd=9.6u ps=9.6u m=1
* device instance $35 r0 *1 123.4,34 pfet
XM__35 M2D PG VDD VDD pfet_03v3 L=4u W=4u nf=1 ad=3.2p as=3.2p pd=9.6u ps=9.6u m=1
* device instance $36 r0 *1 128,34 pfet
XM__36 NB PCAS M2D VDD pfet_03v3 L=1u W=4u nf=1 ad=3.2p as=3.2p pd=9.6u ps=9.6u m=1
* device instance $37 r0 *1 132.6,34 pfet
XM__37 M3D PG VDD VDD pfet_03v3 L=4u W=4u nf=1 ad=3.2p as=3.2p pd=9.6u ps=9.6u m=1
* device instance $38 r0 *1 137.2,34 pfet
XM__38 PTAT PCAS M3D VDD pfet_03v3 L=1u W=4u nf=1 ad=3.2p as=3.2p pd=9.6u ps=9.6u m=1
* device instance $39 r0 *1 140.3,34 pfet
XM__39 PTAT PCAS M3D VDD pfet_03v3 L=1u W=4u nf=1 ad=3.2p as=3.2p pd=9.6u ps=9.6u m=1
* device instance $40 r0 *1 144.9,34 pfet
XM__40 M3D PG VDD VDD pfet_03v3 L=4u W=4u nf=1 ad=3.2p as=3.2p pd=9.6u ps=9.6u m=1
* device instance $41 r0 *1 149.5,34 pfet
XM__41 NB PCAS M2D VDD pfet_03v3 L=1u W=4u nf=1 ad=3.2p as=3.2p pd=9.6u ps=9.6u m=1
* device instance $42 r0 *1 154.1,34 pfet
XM__42 M2D PG VDD VDD pfet_03v3 L=4u W=4u nf=1 ad=3.2p as=3.2p pd=9.6u ps=9.6u m=1
* device instance $43 r0 *1 158.7,34 pfet
XM__43 NA PCAS M1D VDD pfet_03v3 L=1u W=4u nf=1 ad=3.2p as=3.2p pd=9.6u ps=9.6u m=1
* device instance $44 r0 *1 163.3,34 pfet
XM__44 M1D PG VDD VDD pfet_03v3 L=4u W=4u nf=1 ad=3.2p as=3.2p pd=9.6u ps=9.6u m=1
* device instance $45 r0 *1 169.4,34 pfet
XM__45 VDD VDD VDD VDD pfet_03v3 L=4u W=4u nf=1 ad=3.2p as=3.2p pd=9.6u ps=9.6u m=1
* device instance $46 r0 *1 258.95,34 pfet
XM__46 PG EN VDD VDD pfet_03v3 L=0.5u W=4u nf=1 ad=3.2p as=3.2p pd=9.6u ps=9.6u m=1
* device instance $47 r0 *1 185.6,37 pfet
XM__47 PG PB VDD VDD pfet_03v3 L=4u W=10u nf=1 ad=8p as=8p pd=21.6u ps=21.6u m=1
* device instance $48 r0 *1 205.1,37 pfet
XM__48 PB PB VDD VDD pfet_03v3 L=4u W=10u nf=1 ad=8p as=8p pd=21.6u ps=21.6u m=1
* device instance $49 r0 *1 2.8,40 pfet
XM__49 NT NT NT NT pfet_03v3 L=4u W=16u nf=1 ad=12.8p as=12.8p pd=33.6u ps=33.6u m=1
* device instance $50 r0 *1 8.9,40 pfet
XM__50 N1 NA NT NT pfet_03v3 L=4u W=16u nf=1 ad=12.8p as=12.8p pd=33.6u ps=33.6u m=1
* device instance $51 r0 *1 15,40 pfet
XM__51 N2 NB NT NT pfet_03v3 L=4u W=16u nf=1 ad=12.8p as=12.8p pd=33.6u ps=33.6u m=1
* device instance $52 r0 *1 21.1,40 pfet
XM__52 N2 NB NT NT pfet_03v3 L=4u W=16u nf=1 ad=12.8p as=12.8p pd=33.6u ps=33.6u m=1
* device instance $53 r0 *1 27.2,40 pfet
XM__53 N1 NA NT NT pfet_03v3 L=4u W=16u nf=1 ad=12.8p as=12.8p pd=33.6u ps=33.6u m=1
* device instance $54 r0 *1 33.3,40 pfet
XM__54 NT NT NT NT pfet_03v3 L=4u W=16u nf=1 ad=12.8p as=12.8p pd=33.6u ps=33.6u m=1
* device instance $55 r0 *1 41.4,42 pfet
XM__55 NT PB VDD VDD pfet_03v3 L=4u W=20u nf=1 ad=16p as=16p pd=41.6u ps=41.6u m=1

* ---- interconnect parasitics: extracted from the layout ----
* One series R + one lumped C to substrate per net, from the deck's
* curated sheet-resistance / capacitance table (klt extract
* --parasitics). First order, not a field solve.
Rpar_CTAT CTAT CTAT__par 474.74
Cpar_CTAT CTAT__par VSS 2.71954e-14
Rpar_EN EN EN__par 1400.37
Cpar_EN EN__par VSS 3.31567e-14
Rpar_ENB ENB ENB__par 1686.12
Cpar_ENB ENB__par VSS 3.61461e-14
Rpar_IBIAS IBIAS IBIAS__par 322.65
Cpar_IBIAS IBIAS__par VSS 2.02877e-14
Rpar_M1D M1D M1D__par 1180.59
Cpar_M1D M1D__par VSS 2.54308e-14
Rpar_M2D M2D M2D__par 1105.05
Cpar_M2D M2D__par VSS 2.40399e-14
Rpar_M3D M3D M3D__par 1029.53
Cpar_M3D M3D__par VSS 2.26489e-14
Rpar_N1 N1 N1__par 3844.1
Cpar_N1 N1__par VSS 3.85894e-14
Rpar_N2 N2 N2__par 2240.79
Cpar_N2 N2__par VSS 4.40329e-14
Rpar_NA NA NA__par 1928.77
Cpar_NA NA__par VSS 2.90978e-14
Rpar_NB NB NB__par 1853.51
Cpar_NB NB__par VSS 2.77069e-14
Rpar_NBG NBG NBG__par 1144.93
Cpar_NBG NBG__par VSS 2.69461e-14
Rpar_ND ND ND__par 1476.21
Cpar_ND ND__par VSS 3.44808e-14
Rpar_NR NR NR__par 1658.51
Cpar_NR NR__par VSS 3.51105e-14
Rpar_NT NT NT__par 5050.55
Cpar_NT NT__par VSS 7.57243e-14
Rpar_PB PB PB__par 3354.45
Cpar_PB PB__par VSS 4.57031e-14
Rpar_PCAS PCAS PCAS__par 4257.78
Cpar_PCAS PCAS__par VSS 5.14302e-14
Rpar_PG PG PG__par 4774.58
Cpar_PG PG__par VSS 5.91151e-14
Rpar_PTAT PTAT PTAT__par 847.142
Cpar_PTAT PTAT__par VSS 3.05575e-14
Rpar_T0 T0 T0__par 1166.13
Cpar_T0 T0__par VSS 3.95244e-14
Rpar_T1 T1 T1__par 1129.91
Cpar_T1 T1__par VSS 3.93243e-14
Rpar_T2 T2 T2__par 1093.87
Cpar_T2 T2__par VSS 3.91773e-14
Rpar_T3 T3 T3__par 1057.66
Cpar_T3 T3__par VSS 3.89772e-14
Rpar_T4 T4 T4__par 1021.61
Cpar_T4 T4__par VSS 3.88302e-14
Rpar_T5 T5 T5__par 522.434
Cpar_T5 T5__par VSS 3.10047e-14
Rpar_VDD VDD VDD__par 11047.2
Cpar_VDD VDD__par VSS 1.17868e-13
Rpar_VSS VSS VSS__par 3075.86
Cpar_VSS VSS__par VSS 5.5177e-14

* ---- non-MOS devices: IDEAL, verbatim from the schematic ----
* Nodes introduced by these devices alone (they exist in no
* extraction, so they carry no parasitics): NC, NZ
* from temp_core
XCC PG NZ cap_mim_2f0_m3m4_noshield c_width=12u c_length=12u m=1
* from temp_core
XRZ NZ N2 VSS ppolyf_u r_width=2u r_length=1000u m=1
* from temp_core
XQ1 VSS VSS NA pnp_10p00x10p00 m=1
* from temp_core
XQ8A VSS VSS NC pnp_10p00x10p00 m=1
* from temp_core
XQ8B VSS VSS NC pnp_10p00x10p00 m=1
* from temp_core
XQ8C VSS VSS NC pnp_10p00x10p00 m=1
* from temp_core
XQ8D VSS VSS NC pnp_10p00x10p00 m=1
* from temp_core
XQ8E VSS VSS NC pnp_10p00x10p00 m=1
* from temp_core
XQ8F VSS VSS NC pnp_10p00x10p00 m=1
* from temp_core
XQ8G VSS VSS NC pnp_10p00x10p00 m=1
* from temp_core
XQ8H VSS VSS NC pnp_10p00x10p00 m=1
* from temp_core
XR1 NB NC VSS ppolyf_u r_width=2u r_length=119.47u m=1
* from temp_core
XR2F PTAT T5 VSS ppolyf_u r_width=2u r_length=2652.6u m=1
* from temp_core
XR2T5 T5 T4 VSS ppolyf_u r_width=2u r_length=229.71u m=1
* from temp_core
XR2T4 T4 T3 VSS ppolyf_u r_width=2u r_length=114.69u m=1
* from temp_core
XR2T3 T3 T2 VSS ppolyf_u r_width=2u r_length=57.18u m=1
* from temp_core
XR2T2 T2 T1 VSS ppolyf_u r_width=2u r_length=28.42u m=1
* from temp_core
XR2T1 T1 T0 VSS ppolyf_u r_width=2u r_length=14.03u m=1
* from temp_core
XR2T0 T0 VSS VSS ppolyf_u r_width=2u r_length=6.85u m=1
* from temp_core
XRISO NA CTAT VSS ppolyf_u r_width=2u r_length=111.05u m=1

.ends temp_core
