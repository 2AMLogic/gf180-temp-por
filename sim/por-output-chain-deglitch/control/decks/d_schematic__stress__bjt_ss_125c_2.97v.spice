* por-output-chain-deglitch dwell sweep -- schematic @ bjt_ss / 125 C / 2.97 V, IBIAS 91.0251 nA, 600 us dip -- GENERATED by run_dwell_sweep.py, do not edit
* pdk=gf180mcuD@c6d73a35f524070e85faff4a6a9eef49553ebc2b  harness=0.1.0

.param vdd_val=2.97
.param ibias_a=9.10251e-08
.param t_dip_lo=0.0019999
.param t_dip_hi=0.002
.param t_dip_end=0.0026
.param t_dip_up=0.0026000999999999997
.param stop_s=0.0026200999999999998

.include "/Users/rwalters/.volare/gf180mcuD/libs.tech/ngspice/design.ngspice"
.lib "/Users/rwalters/.volare/gf180mcuD/libs.tech/ngspice/sm141064.ngspice" typical
.lib "/Users/rwalters/.volare/gf180mcuD/libs.tech/ngspice/sm141064.ngspice" res_typical
.lib "/Users/rwalters/.volare/gf180mcuD/libs.tech/ngspice/sm141064.ngspice" bjt_ss
.lib "/Users/rwalters/.volare/gf180mcuD/libs.tech/ngspice/sm141064.ngspice" diode_typical
.lib "/Users/rwalters/.volare/gf180mcuD/libs.tech/ngspice/sm141064.ngspice" moscap_typical
.lib "/Users/rwalters/.volare/gf180mcuD/libs.tech/ngspice/sm141064.ngspice" mimcap_typical

.temp 125.0
.options reltol=1e-5
.options abstol=1e-15
.options vntol=1e-8
.options method=gear

.include "../dwell_sweep.spice"
.include "dut_schematic.spice"

.tran 2e-06 {stop_s}

.meas tran pgdg_pre find v(xdut.pgdg) at=0.001999
.meas tran ndg_pre find v(xdut.ndg) at=0.001999
.meas tran t_trip when v(xdut.pgdg)=1.0 fall=1 td=0.002
.meas tran pgdg_min min v(xdut.pgdg) from=0.002 to=0.0026
.meas tran ndg_max max v(xdut.ndg) from=0.002 to=0.0026
.meas tran pgdg_end find v(xdut.pgdg) at=0.0026

.end
