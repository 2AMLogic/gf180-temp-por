* por-ramp-rate internal-node probe @ tt / 27 C / 3.3 V / 1 V/s / arm=asbuilt -- GENERATED by run_chatter_probe.py, do not edit
* pdk=gf180mcuD@c6d73a35f524070e85faff4a6a9eef49553ebc2b

.param vdd_val=3.3
.param rate_v_per_s=1.0
.param stop_s=2.65

.include "/Users/rwalters/.volare/gf180mcuD/libs.tech/ngspice/design.ngspice"
.lib "/Users/rwalters/.volare/gf180mcuD/libs.tech/ngspice/sm141064.ngspice" typical
.lib "/Users/rwalters/.volare/gf180mcuD/libs.tech/ngspice/sm141064.ngspice" res_typical
.lib "/Users/rwalters/.volare/gf180mcuD/libs.tech/ngspice/sm141064.ngspice" bjt_typical
.lib "/Users/rwalters/.volare/gf180mcuD/libs.tech/ngspice/sm141064.ngspice" diode_typical
.lib "/Users/rwalters/.volare/gf180mcuD/libs.tech/ngspice/sm141064.ngspice" moscap_typical
.lib "/Users/rwalters/.volare/gf180mcuD/libs.tech/ngspice/sm141064.ngspice" mimcap_typical

.temp 27.0
.options reltol=1e-4
.options abstol=1e-13
.options vntol=1e-8
.options method=gear

.include "../chatter_probe.spice"
.include "dut_asbuilt.spice"

.tran 2m {stop_s}

.control
set numdgt=10
set noaskquit
run
wrdata trace.csv v(vdd) v(xdut.por_raw) v(xdut.xpor.pgdg) v(xdut.vref) v(xdut.bias_ok) v(resetn) v(xdut.xpor.tim) v(xdut.xpor.nd1) v(xdut.xpor.trip) v(xdut.xpor.rstb) v(xdut.ibias) v(xdut.xpor.pdn) v(xdut.xpor.ndl)
.endc
.end
