* gf180-temp-por batch body -- GENERATED by sim/harness/klt_batch.py
.param vdd_nom=3.3
.param vdd_val=3.63
.param temp_c=27.0
* ---- design.ngspice inlined from the PDK (sha256 091cb530bf85160a...) ----
* Copyright 2022 GlobalFoundries PDK Authors
*
* Licensed under the Apache License, Version 2.0 (the "License");
* you may not use this file except in compliance with the License.
* You may obtain a copy of the License at
*
*     https://www.apache.org/licenses/LICENSE-2.0
*
* Unless required by applicable law or agreed to in writing, software
* distributed under the License is distributed on an "AS IS" BASIS,
* WITHOUT WARRANTIES OR CONDITIONS OF ANY KIND, either express or implied.
* See the License for the specific language governing permissions and
* limitations under the License.

*************************************************************************
** Global Parameter Settings
*************************************************************************
** NGSPICE include file for global switches, corner parameters
** and other user-defined settings
** **********************************************************************
** -------------------------------------------
** MonteCarlo and matching simulation setting:
** -------------------------------------------
** sw_stat_global
** sw_stat_mismatch
**
**   --------------------------------------------------------------------------
**   |       setting        |  sw_stat_global=0     |  sw_stat_global=1       |
**   --------------------------------------------------------------------------
**   |  sw_stat_mismatch=0  | No statistical        | Global variation is on, |
**   |                      |  modeling             | but mismatch is off.    |
**   --------------------------------------------------------------------------
**   |  sw_stat_mismatch=1  | mismacth is on,       | Most realistic          |
**   |                      | global variation off  | distribution.           |
**   --------------------------------------------------------------------------
**
**
**   (default) - sw_stat_global=1 and sw_stat_mismatch=1
**   This setting provides the most complete representation of the
**   statistical variations during chip manufacturing.
**   Global process variations are determined by random distributions.
**   Mismatch is differentiated from global variation in that mismatch only
**   includes intra-die variation, and it is especially critical for analog matching applications.
**
**   mc_skew is the monte-carlo simulation variation control.
**
**
** -------------------------------------------
**       Flicker noise corner setting:
** -------------------------------------------
**
**        "fnoicor" switch is added for user to select between the best- or worst-case
**         flicker noise simulation options
**         fnoicor = 0  : (default) as-extracted simulation
**         fnoicor = 1  : worst case simulation
**
** *****************************************************************************
**
** Switches
**
*********** Default mc switches **********
**
.param
+  sw_stat_global = 0
+  sw_stat_mismatch = 0
**
********* Default mc skew value *********
**
+ mc_skew = 3
+ res_mc_skew = 3
+ cap_mc_skew = 3
**
****** Default flicker noise corner switch *****
**
+  fnoicor = 0
********************************************************************************
* ---- end design.ngspice ----
.options reltol=1e-5
.options abstol=1e-15
.options vntol=1e-8
.options method=gear
* por-output-chain-pulse -- stimulus half of the testbench fragment.
*
* The other half is a verbatim copy of design/netlist/por_output_chain.spice,
* appended by sim/build_tb.py to produce tb_por_pulse.spice. Edit THIS file
* (or the schematic), never the generated fragment.
*
* Netlist FRAGMENT: no .include / .lib / .temp / .control / .end -- the
* harness owns those. Parameters it supplies: vdd_val, vdd_nom, temp_c.
*
* WHAT THIS EXPERIMENT SUBSTANTIATES
*
* spec/target-spec.md#por-reset-pulse: RESETn stays asserted for >=1 ms after
* the release conditions are met, at the FASTEST-timer corner. The pulse here
* is a current-starved ramp (2.5 nA into 6.27 pF), so "fastest" is the corner
* with the most charging current and the least capacitance -- FF / +125 C /
* 3.63 V -- and the whole 81-point grid is swept to prove that is really where
* the minimum lands rather than assuming it.
*
* It also records this cell's share of the shared spec/target-spec.md#por-iq
* budget, sampled in the state that row is defined in (rule 1 of the table's
* section 5): RESETn asserted, rail settled, sensor disabled.
*
* THE IBIAS TOLERANCE PROBLEM, AND WHY THERE ARE TWO DUTS
*
* Every internal current in this cell is a ratio of IBIAS, so the pulse width
* scales as 1/IBIAS. bias_core (#11) has not landed, so its corner spread is
* not yet knowable; asserting >=1 ms against one ideal 0.5 uA source would be
* a result that #11 could silently invalidate later. Instead two identical
* DUTs run side by side on the same rail:
*
*   xdut1  IBIAS = 0.5 uA   the DR-005 nominal (same convention as temp_core:
*                           bias_core SOURCES the current into the pin)
*   xdut2  IBIAS = 1.5 uA   3x nominal -- the stress case for the >=1 ms
*                           minimum, since more bias current means a faster
*                           timer. If xdut2 clears 1 ms at every corner then
*                           the claim survives a 3x IBIAS error from #11.
*
* TIMELINE
*
*   0     -> 100 us   VDD ramps 0 -> vdd_val (~33 kV/s, inside the ratified
*                     por-ramp-rate envelope). POR_RAW held low.
*   100 us-> 1 ms     rail settled, POR_RAW low: this is exactly the por-iq
*                     accounting state. Sampled at 0.9 ms.
*   1.001 ms          POR_RAW steps high -- the release condition. Stepping it
*                     rather than deriving it from the ramp is deliberate: the
*                     pulse is measured from a single unambiguous t0, and
*                     ramp-crossing behaviour is #14's job, not this record's.
*   ...               RESETn must stay low for >=1 ms, then release once.
*   19.5 ms           released-state draw sampled (feeds iq-total, not por-iq)

vsup vdd 0 PWL(0 0 100u {vdd_val} 20m {vdd_val})
vpr  por_raw 0 PWL(0 0 1m 0 1.002m {vdd_val} 20m {vdd_val})

* IBIAS references. Modelled as coming up with the rail rather than as ideal
* DC sources: below ~1.5 V there is no bias core yet (DR-005 startup ordering
* step 3), so forcing current into the pin while the rail is dead would be a
* stimulus artefact. Same construction as sim/temp-core-startup/.
Bib1 vdd nib1 i='500n*min(1, max(0, (v(vdd)-1.5)/0.5))'
vib1 nib1 ibias1 dc 0
Bib2 vdd nib2 i='1500n*min(1, max(0, (v(vdd)-1.5)/0.5))'
vib2 nib2 ibias2 dc 0

* 0 V ammeters in each DUT's own VDD pin. The IBIAS reference is sourced from
* vdd directly, so it does NOT pass through these -- i(vd1) is what this cell
* draws from the rail on its own account, which is the number the por-iq
* budget needs.
vd1 vdd vdd1 dc 0
vd2 vdd vdd2 dc 0

* por-reset-pulse measurement load, provisional per the spec row: 5 pF, no DC
* load. The 1 Tohm is a solver aid, not a load.
Cl1 resetn1 0 5p
Rl1 resetn1 0 1T
Cl2 resetn2 0 5p
Rl2 resetn2 0 1T

xdut1 vdd1 0 ibias1 por_raw resetn1 por_output_chain
xdut2 vdd2 0 ibias2 por_raw resetn2 por_output_chain

.include "dut.spice"
