* tb_por_vth_postlayout -- GENERATED by sim/build_tb.py
* Do not edit. Sources:
*   sim/por-vth/testbench/stimulus.spice
*   layout/postlayout/temp_por_top.spice  (sha256 ae942ea399740d9a2ebc16511ad9edf0aad4865782eb4478c283619fc6320a54)
* Regenerate with:
*   python3 sim/build_tb.py

* por-vth -- stimulus half of the testbench fragment.
*
* The other half is a verbatim copy of design/netlist/temp_por_top.spice,
* appended by sim/build_tb.py to produce tb_por_vth.spice. That one file
* already carries every sub-circuit definition the top level instantiates, so
* this DUT is the WHOLE assembled block (bias_core + temp_core +
* por_comparator + por_output_chain), with nothing idealised. Edit THIS file
* (or the schematics), never the generated fragment.
*
* Netlist FRAGMENT: no .include / .lib / .temp / .control / .end -- the
* harness owns those. Parameters it supplies: vdd_val, vdd_nom, temp_c, plus
* `dvdd_dt_v_per_s` from ../testbench/tb.json's `params` map (issue #206).
*
* WHAT THIS EXPERIMENT SUBSTANTIATES
*
* spec/target-spec.md#por-vth-rise, #por-vth-fall, #por-hysteresis --
* corner-worst-case (deterministic, not Monte Carlo) extraction of the
* release/assert threshold pair and the hysteresis, on the FULL ASSEMBLY
* rather than the idealised-VREF/IBIAS cell-level check
* sim/por-comparator-designer-check/ already ran. That record's own text
* names this exact gap: "IBIAS/VREF are idealised fixed stimuli standing in
* for bias_core ... Full ramp-rate/brownout/reset-pulse-interaction evidence
* against a real (non-idealised) startup sequence remains #14's job." This
* deck answers the threshold/hysteresis half of that with bias_core's real
* (corner-dependent, ~1.19-1.21 V per sim/temp-por-top-release/) VREF in the
* loop instead of an idealised 1.2 V source.
*
* Measured on the internal POR_RAW node (v(xdut.por_raw)), not RESETn: RESETn
* only deasserts after por_output_chain's deglitch dwell and >=1 ms one-shot
* have both elapsed (sim/por-output-chain-pulse/, sim/temp-por-top-release/
* measures 5.6-17.0 ms end to end on the assembly), so measuring the
* threshold off RESETn would fold that unrelated timing into a voltage claim.
* POR_RAW is the comparator's own decision, which is what "release/assert
* threshold" means in spec/target-spec.md section 4.1.
*
* Corner-worst-case only: design.ngspice sets sw_stat_mismatch=0, so this is
* the SYSTEMATIC/corner term. The [3sigma] mismatch share stays #15's job,
* exactly as sim/por-comparator-designer-check/ already states -- this record
* does not change that row's `conditional #15` status, only its full-assembly
* evidence.
*
* RAMP RATE: dVDD/dt CONSTANT ACROSS THE SUPPLY AXIS (issue #206). A prior
* revision of this deck traversed 2.0 V -> vdd_val -> 2.0 V in a FIXED 4 ms,
* so its dVDD/dt was itself a function of vdd_val -- 242.5 / 325 / 407.5 V/s
* at 2.97 / 3.30 / 3.63 V, a 1.68x spread -- and the supply axis of the
* 81-point grid was simultaneously a ramp-rate axis. No measurement on that
* grid could separate "this corner's threshold is different" from "this
* corner's rail moved faster while crossing it": `sim/por-vth/records/
* 20260811-073945-12473c3.md` reported `v_hys_mv` = 261.092 mV at
* `ss_-40c_3.63v` (its fastest-ramped point, 407.5 V/s), of which
* `sim/por-vth/control/results.md` (issue #187/#218, DR-021) shows only
* ~143 mV is the divider's static hysteresis -- the rest is `bias_core`'s
* VREF being displaced by the moving rail (~37 %) plus comparator/
* output-chain delay (~8 %), not hysteresis. This deck's own
* `sim/por-vth/control/rate_selection_results.md` (issue #206) reproduces
* the same ~144 mV zero-rate limit independently, at the two specific rates
* (242.5 / 121.25 V/s) this fix uses.
*
* The duration of each quasi-static segment is now DERIVED from a constant
* `dvdd_dt_v_per_s` (a manifest parameter, ../testbench/tb.json's `params`):
* `tramp = (vdd_val - 2.0) / dvdd_dt_v_per_s`. One variable per axis: the
* supply axis sweeps vdd_val only, and every corner traverses its threshold
* band at the SAME rate.
*
* RATE CHOICE: 242.5 V/s -- not a new number, the fastest-ramped record's OWN
* slowest column (its 2.97 V corner already ran the 2.0 V -> vdd_val leg at
* exactly this rate under the old fixed-4-ms scheme, so 2.97 V's reading is
* bit-for-bit unchanged by this fix). `sim/por-vth/control/
* rate_selection_results.md`'s rate ladder at the binding corner
* (`ss` / -40 C / 3.63 V) measures the
* residual displacement this choice still carries: `V_hys` = 215.660 mV
* (extracted) / 206.850 mV (schematic) at 242.5 V/s, against a 144.190 /
* 143.700 mV zero-rate limit and the historical 407.5 V/s record's
* 261.090 / 248.740 mV. Rate-matched across the whole supply window at
* 242.5 V/s, that same control shows `VPOR-uparrow` spreads 0.000 mV
* (identical at all three supplies) and `V_hys` spreads 4.280 mV, against the
* pre-fix grid's 20.64 mV / 49.710 mV -- both driven by ramp rate, not by
* supply, per that control's arm C. 243-408 V/s (the old scheme's full
* range) is also the same order as the 121 V/s primary and 484 V/s
* 4x-replica branches `sim/bias-core-startup/` validates as rate-independent
* in that context, but this deck's own control shows `bias_core`'s reference
* IS displaced by ramp rate through this exact node under this deck's own
* loading -- so that comparison bounds plausibility, it is not itself
* evidence of rate-independence here, and this fix does not repeat the
* claim.
*
* QUASI-STATICITY GUARD (issue #206, acceptance criterion 3): a claim of
* "quasi-static" that is not itself checked is exactly the failure mode this
* issue reports. After the primary rise/hold/fall cycle above, the deck
* appends a SECOND rise/hold/fall cycle at HALF the rate (`dvdd_dt_v_per_s`/2,
* i.e. 121.25 V/s at this deck's chosen rate) over the same 2.0 V ->
* vdd_val -> 2.0 V span. `../testbench/tb.json`'s
* `v_hys_rate_guard_delta_mv` check bounds how far the primary segment's
* `V_hys` may differ from the guard segment's own `V_hys` -- the same control
* ladder measures that gap at the binding corner (242.5 V/s vs. 121.25 V/s):
* 34.830 mV (extracted) / 31.310 mV (schematic), so a future stimulus edit
* that reintroduces a fixed-duration (rate-varies-with-supply) scheme, or
* otherwise makes this deck non-quasi-static again, fails that check loudly
* instead of silently re-confounding the supply axis. `rise_chatter_guard_ms`
* / `fall_chatter_guard_ms` (below) additionally confirm the guard segment's
* own crossings are found where expected, which doubles as the pre-existing
* anti-chatter guard on the primary edges (see CROSSING COUNTING below).
*
* Starting the slow segment at 2.0 V is safe for the crossing detection:
* sim/por-comparator-designer-check/ measures POR_RAW at a 2 V rail at
* 6.8e-6 to 6.7e-5 mV over the whole grid (`por_at_2v_mv`), i.e. a hard
* logic low six decades below this deck's 1.5 V crossing level, so the
* first rising crossing cannot land in the fast segment.
*
* THE RAIL STOPS AT 2.0 V, IT DOES NOT COLLAPSE TO 0 V. VPOR-downarrow,min
* is 2.22 V, so a down-ramp that stops at 2.0 V clears the ratified assert
* threshold by >=0.22 V at every corner and captures the falling crossing.
* Continuing to 0 V would add nothing to this claim -- the below-floor
* behaviour of POR_RAW is sim/por-comparator-designer-check/'s
* `por_at_0p5v`/`por_at_1v` probes, and the below-floor RESETn valid-low
* claim is sim/por-output-chain-floor/'s and sim/por-brownout/'s -- while
* making the deck several times more expensive to solve (the assembled
* block in deep collapse is where ngspice spends nearly all of its time on
* this netlist). Cheap evidence that is in scope beats expensive evidence
* that duplicates three existing records.
*
* CROSSING COUNTING: POR_RAW=1.5V now crosses FOUR times per run (primary
* rise, primary fall, guard rise, guard fall) instead of two, so the
* pre-existing anti-chatter guard -- originally "does the first crossing on
* an edge equal the LAST crossing anywhere in the trace" -- can no longer use
* `rise=last`/`fall=last`: the guard segment's own (legitimate) second rise
* and fall are always later in time than anything on the primary edges, so
* `last` would always pick the guard's crossing and the check would stop
* detecting a real double-bounce on the primary edge. Instead,
* `../testbench/tb.json` measures the TIME of the ordinal-second crossing
* (`rise=2`/`fall=2`, whatever produces it) and checks that it lands no
* earlier than 16 ms -- comfortably after the primary segment's own crossing
* window (which ends by 7.7216 ms at this deck's slowest corner, VDD=3.63 V)
* and comfortably before every corner's guard segment can start (which
* begins no earlier than 17 ms, at VDD=2.97 V, this deck's fastest-settling
* corner). A primary-edge double-bounce would put the ordinal-second
* crossing inside the primary ramp instead (well under 8 ms), failing that
* floor; `vpor_rise_guard`/`vpor_fall_guard` reuse the same ordinal-2
* crossings for their VALUE (`find v(vdd) ... rise=2`/`fall=2`), so a
* passing `rise_chatter_guard_ms`/`fall_chatter_guard_ms` is also what makes
* those two guard-segment readings trustworthy.
*
* TIMESTEP: the manifest asks for `tran 10u 55m`. On the quasi-static
* segments the rail moves proportionally to `dvdd_dt_v_per_s` per step, and
* the quantity extracted is not the step grid but the rail voltage at the
* instant POR_RAW crosses 1.5 V -- a hysteretic comparator edge that resolves
* in microseconds, so local truncation error refines the step by orders of
* magnitude across the crossing itself and `meas ... when` interpolates
* between the refined points. The ceiling therefore bounds solve cost on the
* flat holds, not the resolution of any of the four thresholds.
*
* PAD LOAD: 1 pF plus a 1 Tohm DC leak on each of PTAT and CTAT, matching
* sim/temp-por-top-release/ and sim/temp-accuracy-vt/ exactly. The resistors
* are not a model of anything physical -- they are the DC reference the two
* analogue pads need in the state this deck spends most of its time in.
* While RESETn is asserted temp_core is disabled and its outputs are high
* impedance (DR-010's disabled-consumer contract), so without them PTAT and
* CTAT are capacitively coupled floating nodes, and ngspice's local
* truncation error control collapses the timestep trying to track them: an
* early revision of these decks, identical but for these four lines, ran
* >450 s of CPU per PVT point without completing, against ~36 s for the
* comparable 30 ms transient in sim/temp-por-top-release/. 1 Tohm at a
* ~1.3 V pad is 1.3 pA, four to five orders of magnitude below the block's
* own nanoamp-scale currents, so it references the node without loading it.
*
* ONE DUT, ONE (DOUBLE) TRIANGLE WAVE -- half the circuit size of the
* two-DUT idiom sim/por-comparator-designer-check/ and sim/bias-core-startup/
* use elsewhere in this repo, chosen here because the full four-cell
* assembly is far more expensive per point than a single sub-circuit: a
* single DUT cold-starts, ramps up (VPOR-uparrow), settles, then ramps back
* down (VPOR-downarrow) at the SAME corner point, on the SAME instance, then
* repeats the up/down cycle once more at half the rate for the guard, so
* "same corner point" is exact by construction, not merely by using
* identical corner libs across separate instances or separate runs.
*
*   PRIMARY SEGMENT (dvdd_dt_v_per_s, the production rate):
*     0     -> t_a    cold start: VDD ramps 0 -> 2.0 V at 2000 V/s. Below
*                      every corner's assert threshold throughout, POR_RAW
*                      never leaves its hard low (see above).
*     t_a   -> t_b    VDD ramps 2.0 V -> vdd_val quasi-statically at
*                      dvdd_dt_v_per_s -- VPOR-uparrow, measured off
*                      v(xdut.por_raw).
*     t_b   -> t_c    held at vdd_val for 6 ms -- rail settled, reference
*                      settled. POR_RAW is the comparator's own decision and
*                      has already resolved on the up-ramp; this hold exists
*                      so both VREF samples below are taken on a settled
*                      reference and so the down-ramp starts from a
*                      genuinely static state.
*     t_c   -> t_d    VDD ramps vdd_val -> 2.0 V quasi-statically at the same
*                      rate -- VPOR-downarrow, measured off the SAME
*                      v(xdut.por_raw), at the SAME corner point as the rise
*                      above.
*     t_d   -> t_e    held at 2.0 V for 2 ms -- tail observation margin,
*                      below every corner's assert threshold.
*   GUARD SEGMENT (dvdd_dt_v_per_s / 2, half the production rate):
*     t_e   -> t_f    VDD ramps 2.0 V -> vdd_val quasi-statically at HALF the
*                      production rate -- VPOR-uparrow (guard).
*     t_f   -> t_g    held at vdd_val for 2 ms.
*     t_g   -> t_h    VDD ramps vdd_val -> 2.0 V quasi-statically at the same
*                      half rate -- VPOR-downarrow (guard).
*     t_h   -> t_i    held at 2.0 V for 2 ms -- final tail margin.
*
* V_hys = VPOR-uparrow - VPOR-downarrow follows directly from the two
* primary edges; the guard segment's own V_hys is the same subtraction on
* the guard edges, and `v_hys_rate_guard_delta_mv` differences the two.

.param t_pre=1m
.param tramp='(vdd_val-2.0)/dvdd_dt_v_per_s'
.param t_hold=6m
.param t_tail=2m
.param t_hold_guard=2m
.param tramp_guard='2*tramp'

.param t_a='t_pre'
.param t_b='t_a+tramp'
.param t_c='t_b+t_hold'
.param t_d='t_c+tramp'
.param t_e='t_d+t_tail'
.param t_f='t_e+tramp_guard'
.param t_g='t_f+t_hold_guard'
.param t_h='t_g+tramp_guard'
.param t_i='t_h+t_tail'

* vref_settle_early/late, por_raw_top and vdd_top (../testbench/tb.json's
* `analyses`) sample the primary hold at FIXED absolute times (8.0 ms /
* 10.9 ms) rather than at an offset from t_b/t_c: those `meas` lines are
* interactive commands inside the harness's `.control` block, which ngspice's
* numparam substitution does not reach (it only rewrites netlist-scope text,
* so a `{t_b+0.5m}` written there does not resolve), and a netlist-scope
* `.meas` does not work either -- ngspice-46 re-evaluates every netlist-scope
* `.measure` a second time after `.control` exits, once the active plot is
* gone, which turns each of those four into a hard "vector ... not available"
* error rather than a value. 8.0-10.9 ms is the intersection of the primary
* hold window [t_b, t_c] across all three ratified supplies at this deck's
* chosen dvdd_dt_v_per_s (2.97 V: [5.0, 11.0] ms; 3.30 V: [6.36, 12.36] ms;
* 3.63 V: [7.72, 13.72] ms -- the binding constraint at both ends), so both
* samples land inside every corner's hold regardless of vdd_val.
vsup vdd 0 PWL(0 0 {t_a} 2.0 {t_b} {vdd_val} {t_c} {vdd_val} {t_d} 2.0 {t_e} 2.0
+ {t_f} {vdd_val} {t_g} {vdd_val} {t_h} 2.0 {t_i} 2.0)
Cpp ptat 0 1p
Cpc ctat 0 1p
Rlp ptat 0 1T
Rlc ctat 0 1T
Crn resetn 0 5p
xdut vdd 0 ptat ctat resetn temp_por_top

* temp_por_top -- post-layout netlist
* GENERATED by layout/postlayout.py -- do not edit.
*
* FROM THE LAYOUT: every device and its dimensions, the whole
*   topology, and first-order interconnect R/C on 136/145 nets
*   (sigma 5900.6 fF). klt 0.2.0, deck gf180mcu,
*   GDS sha256 a119a12b1fa2daff...
* Net names are the schematic's, restored through klt lvs's own net
*   correspondence -- match, 145/145 nets, every one paired.
*
* NOT FROM THE LAYOUT -- see layout/postlayout/AUDIT.md:
*   9 body/plate net(s) tied to the net the schematic puts
*   them on. The extraction deck's connectivity stack does not reach
*   an Nwell, a substrate ring, a bipolar base well or a MiM plate,
*   so they extract isolated and would otherwise float.
*   No ideal device: every golden device is drawn.
*
.subckt temp_por_top VDD VSS PTAT CTAT RESETn

* --- drawn devices ---
X1 xbias__NBG xbias__NBG VSS VSS nfet_03v3 L=4u W=2u nf=1 ad=1.6p as=1.6p pd=5.6u ps=5.6u m=1
X2 xbias__PB xbias__NBG VSS VSS nfet_03v3 L=4u W=2u nf=1 ad=1.6p as=1.6p pd=5.6u ps=5.6u m=1
X3 xbias__N1 xbias__N1 VSS VSS nfet_03v3 L=8u W=4u nf=1 ad=3.2p as=3.2p pd=9.6u ps=9.6u m=1
X4 xbias__N2 xbias__N1 VSS VSS nfet_03v3 L=8u W=4u nf=1 ad=3.2p as=3.2p pd=9.6u ps=9.6u m=1
X5 xbias__PG xbias__N2 VSS VSS nfet_03v3 L=8u W=8u nf=1 ad=6.4p as=6.4p pd=17.6u ps=17.6u m=1
X6 VDD VDD xbias__KS1 VSS nfet_03v3 L=8u W=1u nf=1 ad=0.8p as=0.8p pd=3.6u ps=3.6u m=1
X7 xbias__KS1 xbias__KS1 xbias__KS2 VSS nfet_03v3 L=8u W=1u nf=1 ad=0.8p as=0.8p pd=3.6u ps=3.6u m=1
X8 xbias__KS2 xbias__KS2 xbias__KS3 VSS nfet_03v3 L=8u W=1u nf=1 ad=0.8p as=0.8p pd=3.6u ps=3.6u m=1
X9 xbias__KS3 xbias__KS3 xbias__KS4 VSS nfet_03v3 L=8u W=1u nf=1 ad=0.8p as=0.8p pd=3.6u ps=3.6u m=1
X10 xbias__KS4 xbias__KS4 xbias__NKG VSS nfet_03v3 L=8u W=1u nf=1 ad=0.8p as=0.8p pd=3.6u ps=3.6u m=1
X11 xbias__NKM xbias__NKM VSS VSS nfet_03v3 L=4u W=2u nf=1 ad=1.6p as=1.6p pd=5.6u ps=5.6u m=1
X12 xbias__NKG xbias__NKM VSS VSS nfet_03v3 L=4u W=8u nf=1 ad=6.4p as=6.4p pd=17.6u ps=17.6u m=1
X13 xbias__PG xbias__NKG VSS VSS nfet_03v3 L=4u W=1u nf=1 ad=0.8p as=0.8p pd=3.6u ps=3.6u m=1
X14 xbias__NOKL xbias__NOKL VSS VSS nfet_03v3 L=4u W=2u nf=1 ad=1.6p as=1.6p pd=5.6u ps=5.6u m=1
X15 xbias__NOKO xbias__NOKL VSS VSS nfet_03v3 L=4u W=2u nf=1 ad=1.6p as=1.6p pd=5.6u ps=5.6u m=1
X16 xbias__NOKO xbias__NKG VSS VSS nfet_03v3 L=1u W=2u nf=1 ad=1.6p as=1.6p pd=5.6u ps=5.6u m=1
X17 xbias__NOKX xbias__NOKO VSS VSS nfet_03v3 L=4u W=2u nf=1 ad=1.6p as=1.6p pd=5.6u ps=5.6u m=1
X18 BIAS_OK xbias__NOKX VSS VSS nfet_03v3 L=0.5u W=4u nf=1 ad=3.2p as=3.2p pd=9.6u ps=9.6u m=1
X19 xcmp__NA xcmp__SNS xcmp__TN VSS nfet_03v3 L=1u W=2u nf=1 ad=1.6p as=1.6p pd=5.6u ps=5.6u m=1
X20 xcmp__CMPO VREF xcmp__TN VSS nfet_03v3 L=1u W=2u nf=1 ad=1.6p as=1.6p pd=5.6u ps=5.6u m=1
X21 xcmp__TN xcmp__NBG VSS VSS nfet_03v3 L=10u W=1u nf=1 ad=0.8p as=0.8p pd=3.6u ps=3.6u m=1
X22 IBIAS xcmp__NBG VSS VSS nfet_03v3 L=2u W=2u nf=1 ad=1.6p as=1.6p pd=5.6u ps=5.6u m=1
X23 IBIAS BIAS_OK xcmp__NBG VSS nfet_03v3 L=0.5u W=2u nf=1 ad=1.6p as=1.6p pd=5.6u ps=5.6u m=1
X24 xcmp__NBG xcmp__BIAS_OKB VSS VSS nfet_03v3 L=0.5u W=2u nf=1 ad=1.6p as=1.6p pd=5.6u ps=5.6u m=1
X25 IBIAS xcmp__BIAS_OKB VSS VSS nfet_03v3 L=1u W=1u nf=1 ad=0.8p as=0.8p pd=3.6u ps=3.6u m=1
X26 xcmp__SNSB xcmp__N1 VSS VSS nfet_03v3 L=0.5u W=10u nf=1 ad=8p as=8p pd=21.6u ps=21.6u m=1
X27 xcmp__CMPO xcmp__BIAS_OKB VSS VSS nfet_03v3 L=1u W=2u nf=1 ad=1.6p as=1.6p pd=5.6u ps=5.6u m=1
X28 xcmp__N1 xcmp__CMPO VSS VSS nfet_03v3 L=0.5u W=1u nf=1 ad=0.8p as=0.8p pd=3.6u ps=3.6u m=1
X29 POR_RAW xcmp__N1 VSS VSS nfet_03v3 L=0.5u W=1u nf=1 ad=0.8p as=0.8p pd=3.6u ps=3.6u m=1
X30 xcmp__BIAS_OKB BIAS_OK VSS VSS nfet_03v3 L=0.5u W=1u nf=1 ad=0.8p as=0.5p pd=3.6u ps=3u m=1
X31 IBIAS IBIAS VSS VSS nfet_03v3 L=4u W=4u nf=1 ad=3.2p as=3.2p pd=9.6u ps=9.6u m=1
X32 xpor__PDN IBIAS VSS VSS nfet_03v3 L=25u W=0.5u nf=1 ad=0.4p as=0.4p pd=2.6u ps=2.6u m=1
X33 xpor__NDL xpor__NDL VSS VSS nfet_03v3 L=10u W=2u nf=1 ad=1.6p as=1.6p pd=5.6u ps=5.6u m=1
X34 xpor__NDGN xpor__NDL VSS VSS nfet_03v3 L=10u W=10u nf=1 ad=8p as=8p pd=21.6u ps=21.6u m=1
X35 xpor__NDG POR_RAW xpor__NDGN VSS nfet_03v3 L=0.5u W=1u nf=1 ad=0.8p as=0.8p pd=3.6u ps=3.6u m=1
X36 xpor__PGDG xpor__NDG VSS VSS nfet_03v3 L=0.5u W=2u nf=1 ad=1.6p as=1.6p pd=5.6u ps=5.6u m=1
X37 xpor__PGDGB xpor__PGDG VSS VSS nfet_03v3 L=2u W=0.5u nf=1 ad=0.4p as=0.4p pd=2.6u ps=2.6u m=1
X38 xpor__TIM xpor__PGDGB VSS VSS nfet_03v3 L=1u W=1u nf=1 ad=0.8p as=0.8p pd=3.6u ps=3.6u m=1
X39 xpor__ND1 xpor__NDL VSS VSS nfet_03v3 L=10u W=0.5u nf=1 ad=0.4p as=0.4p pd=2.6u ps=2.6u m=1
X40 xpor__TRIP xpor__ND1 VSS VSS nfet_03v3 L=1u W=1u nf=1 ad=0.8p as=0.8p pd=3.6u ps=3.6u m=1
X41 xpor__ND1 RESETn VSS VSS nfet_03v3 L=1u W=1u nf=1 ad=0.8p as=0.8p pd=3.6u ps=3.6u m=1
X42 xpor__RSTB xpor__TRIP xpor__NNAND VSS nfet_03v3 L=0.5u W=2u nf=1 ad=1.6p as=1.6p pd=5.6u ps=5.6u m=1
X43 xpor__NNAND xpor__PGDG VSS VSS nfet_03v3 L=0.5u W=2u nf=1 ad=1.6p as=1.6p pd=5.6u ps=5.6u m=1
X44 RESETn xpor__RSTB VSS VSS nfet_03v3 L=0.5u W=10u nf=1 ad=8p as=8p pd=21.6u ps=21.6u m=1
X45 VSS VSS VSS VSS nfet_03v3 L=8u W=4u nf=1 ad=3.2p as=3.2p pd=9.6u ps=9.6u m=1
X46 xtemp__N1 xtemp__N1 VSS VSS nfet_03v3 L=8u W=4u nf=1 ad=3.2p as=3.2p pd=9.6u ps=9.6u m=1
X47 xtemp__N2 xtemp__N1 VSS VSS nfet_03v3 L=8u W=4u nf=1 ad=3.2p as=3.2p pd=9.6u ps=9.6u m=1
X48 xtemp__N2 xtemp__N1 VSS VSS nfet_03v3 L=8u W=4u nf=1 ad=3.2p as=3.2p pd=9.6u ps=9.6u m=1
X49 xtemp__N1 xtemp__N1 VSS VSS nfet_03v3 L=8u W=4u nf=1 ad=3.2p as=3.2p pd=9.6u ps=9.6u m=1
X50 VSS VSS VSS VSS nfet_03v3 L=8u W=4u nf=1 ad=3.2p as=3.2p pd=9.6u ps=9.6u m=1
X51 xtemp__PG xtemp__N2 VSS VSS nfet_03v3 L=8u W=8u nf=1 ad=6.4p as=6.4p pd=17.6u ps=17.6u m=1
X52 IBIAS xtemp__NBG VSS VSS nfet_03v3 L=2u W=4u nf=1 ad=3.2p as=3.2p pd=9.6u ps=9.6u m=1
X53 IBIAS RESETn xtemp__NBG VSS nfet_03v3 L=0.5u W=2u nf=1 ad=1.6p as=1.6p pd=5.6u ps=5.6u m=1
X54 xtemp__NBG xtemp__ENB VSS VSS nfet_03v3 L=0.5u W=2u nf=1 ad=1.6p as=1.6p pd=5.6u ps=5.6u m=1
X55 xtemp__PB xtemp__NBG VSS VSS nfet_03v3 L=2u W=4u nf=1 ad=3.2p as=3.2p pd=9.6u ps=9.6u m=1
X56 xtemp__PCAS xtemp__NBG VSS VSS nfet_03v3 L=2u W=4u nf=1 ad=3.2p as=3.2p pd=9.6u ps=9.6u m=1
X57 xtemp__ENB RESETn VSS VSS nfet_03v3 L=0.5u W=1u nf=1 ad=0.8p as=0.8p pd=3.6u ps=3.6u m=1
X58 xtemp__ND xtemp__NR VSS VSS nfet_03v3 L=2u W=2u nf=1 ad=1.6p as=1.6p pd=5.6u ps=5.6u m=1
X59 xtemp__PG xtemp__ND VSS VSS nfet_03v3 L=1u W=4u nf=1 ad=3.2p as=3.2p pd=9.6u ps=9.6u m=1
X60 xtemp__NR xtemp__NR VSS VSS nfet_03v3 L=2u W=2u nf=1 ad=1.6p as=1.6p pd=5.6u ps=5.6u m=1
X61 xtemp__ND xtemp__ENB VSS VSS nfet_03v3 L=0.5u W=2u nf=1 ad=1.6p as=1.6p pd=5.6u ps=5.6u m=1
X62 PTAT xtemp__ENB VSS VSS nfet_03v3 L=1u W=1u nf=1 ad=0.8p as=0.8p pd=3.6u ps=3.6u m=1
X63 CTAT xtemp__ENB VSS VSS nfet_03v3 L=1u W=1u nf=1 ad=0.8p as=0.8p pd=3.6u ps=3.6u m=1
X64 xtemp__N2 xtemp__ENB VSS VSS nfet_03v3 L=1u W=2u nf=1 ad=1.6p as=1.6p pd=5.6u ps=5.6u m=1
X65 xtemp__NT xtemp__ENB VSS VSS nfet_03v3 L=1u W=2u nf=1 ad=1.6p as=1.6p pd=5.6u ps=5.6u m=1
X66 xtemp__T5 VDD xtemp__T4 VSS nfet_03v3 L=0.5u W=32u nf=1 ad=25.6p as=25.6p pd=65.6u ps=65.6u m=1
X67 xtemp__T3 VSS xtemp__T2 VSS nfet_03v3 L=0.5u W=32u nf=1 ad=25.6p as=25.6p pd=65.6u ps=65.6u m=1
X68 xtemp__T1 VSS xtemp__T0 VSS nfet_03v3 L=0.5u W=32u nf=1 ad=25.6p as=25.6p pd=65.6u ps=65.6u m=1
X69 xtemp__T0 VSS VSS VSS nfet_03v3 L=0.5u W=32u nf=1 ad=25.6p as=25.6p pd=65.6u ps=65.6u m=1
X70 xtemp__T2 VSS xtemp__T1 VSS nfet_03v3 L=0.5u W=32u nf=1 ad=25.6p as=25.6p pd=65.6u ps=65.6u m=1
X71 xtemp__T4 VSS xtemp__T3 VSS nfet_03v3 L=0.5u W=32u nf=1 ad=25.6p as=25.6p pd=65.6u ps=65.6u m=1
X72 xbias__NA xbias__PG VDD VDD pfet_03v3 L=4u W=8u nf=1 ad=6.4p as=6.4p pd=17.6u ps=17.6u m=1
X73 xbias__NBTOP xbias__PG VDD VDD pfet_03v3 L=4u W=8u nf=1 ad=6.4p as=6.4p pd=17.6u ps=17.6u m=1
X74 VREF xbias__PG VDD VDD pfet_03v3 L=4u W=8u nf=1 ad=6.4p as=6.4p pd=17.6u ps=17.6u m=1
X75 xbias__NBG xbias__PG VDD VDD pfet_03v3 L=4u W=2u nf=1 ad=1.6p as=1.6p pd=5.6u ps=5.6u m=1
X76 xbias__PB xbias__PB VDD VDD pfet_03v3 L=4u W=2u nf=1 ad=1.6p as=1.6p pd=5.6u ps=5.6u m=1
X77 IBIAS xbias__PB VDD VDD pfet_03v3 L=4u W=40u nf=1 ad=32p as=32p pd=81.6u ps=81.6u m=1
X78 xbias__NT xbias__PB VDD VDD pfet_03v3 L=4u W=2u nf=1 ad=1.6p as=1.6p pd=5.6u ps=5.6u m=1
X79 xbias__N1 xbias__NA xbias__NT VDD pfet_03v3 L=4u W=16u nf=1 ad=12.8p as=12.8p pd=33.6u ps=33.6u m=1
X80 xbias__N2 xbias__NB xbias__NT VDD pfet_03v3 L=4u W=16u nf=1 ad=12.8p as=12.8p pd=33.6u ps=33.6u m=1
X81 xbias__PG xbias__PB VDD VDD pfet_03v3 L=4u W=2u nf=1 ad=1.6p as=1.6p pd=5.6u ps=5.6u m=1
X82 xbias__NKM xbias__PB VDD VDD pfet_03v3 L=4u W=1u nf=1 ad=0.8p as=0.8p pd=3.6u ps=3.6u m=1
X83 xbias__TOK xbias__PB VDD VDD pfet_03v3 L=4u W=1u nf=1 ad=0.8p as=0.8p pd=3.6u ps=3.6u m=1
X84 xbias__NOKO xbias__NA xbias__TOK VDD pfet_03v3 L=4u W=8u nf=1 ad=6.4p as=6.4p pd=17.6u ps=17.6u m=1
X85 xbias__NOKL xbias__NBTOP xbias__TOK VDD pfet_03v3 L=4u W=8u nf=1 ad=6.4p as=6.4p pd=17.6u ps=17.6u m=1
X86 xbias__NOKX xbias__PB VDD VDD pfet_03v3 L=4u W=1u nf=1 ad=0.8p as=0.8p pd=3.6u ps=3.6u m=1
X87 BIAS_OK xbias__NOKX VDD VDD pfet_03v3 L=4u W=1u nf=1 ad=0.8p as=0.8p pd=3.6u ps=3.6u m=1
X88 xcmp__NA xcmp__NA xcmp__VDDA VDD pfet_03v3 L=1u W=4u nf=1 ad=3.2p as=3.2p pd=9.6u ps=9.6u m=1
X89 xcmp__CMPO xcmp__NA xcmp__VDDA VDD pfet_03v3 L=1u W=4u nf=1 ad=3.2p as=3.2p pd=9.6u ps=9.6u m=1
X90 xcmp__VDDA xcmp__BIAS_OKB VDD VDD pfet_03v3 L=0.5u W=4u nf=1 ad=3.2p as=3.2p pd=9.6u ps=9.6u m=1
X91 xcmp__N1 xcmp__CMPO VDD VDD pfet_03v3 L=0.5u W=2u nf=1 ad=1.6p as=1.6p pd=5.6u ps=5.6u m=1
X92 POR_RAW xcmp__N1 VDD VDD pfet_03v3 L=0.5u W=2u nf=1 ad=1.6p as=1.6p pd=5.6u ps=5.6u m=1
X93 xpor__PDN xpor__PDN VDD VDD pfet_03v3 L=10u W=2u nf=1 ad=1.6p as=1.6p pd=5.6u ps=5.6u m=1
X94 xpor__NDL xpor__PDN VDD VDD pfet_03v3 L=10u W=2u nf=1 ad=1.6p as=1.6p pd=5.6u ps=5.6u m=1
X95 xpor__NDGP xpor__PDN VDD VDD pfet_03v3 L=10u W=10u nf=1 ad=8p as=8p pd=21.6u ps=21.6u m=1
X96 xpor__NTS xpor__PDN VDD VDD pfet_03v3 L=10u W=0.5u nf=1 ad=0.4p as=0.4p pd=2.6u ps=2.6u m=1
X97 xpor__TRIP xpor__PDN VDD VDD pfet_03v3 L=10u W=0.5u nf=1 ad=0.4p as=0.4p pd=2.6u ps=2.6u m=1
X98 xpor__NDG POR_RAW xpor__NDGP VDD pfet_03v3 L=0.5u W=1u nf=1 ad=0.8p as=0.8p pd=3.6u ps=3.6u m=1
X99 xpor__PGDG xpor__NDG VDD VDD pfet_03v3 L=2u W=0.5u nf=1 ad=0.4p as=0.4p pd=2.6u ps=2.6u m=1
X100 xpor__PGDGB xpor__PGDG VDD VDD pfet_03v3 L=0.5u W=2u nf=1 ad=1.6p as=1.6p pd=5.6u ps=5.6u m=1
X101 xpor__TIM xpor__PGDGB xpor__NTS VDD pfet_03v3 L=1u W=2u nf=1 ad=1.6p as=1.6p pd=5.6u ps=5.6u m=1
X102 xpor__ND1 xpor__TIM VDD VDD pfet_03v3 L=1u W=2u nf=1 ad=1.6p as=1.6p pd=5.6u ps=5.6u m=1
X103 xpor__RSTB xpor__TRIP VDD VDD pfet_03v3 L=0.5u W=4u nf=1 ad=3.2p as=3.2p pd=9.6u ps=9.6u m=1
X104 xpor__RSTB xpor__PGDG VDD VDD pfet_03v3 L=0.5u W=4u nf=1 ad=3.2p as=3.2p pd=9.6u ps=9.6u m=1
X105 xpor__RSTB RESETn VDD VDD pfet_03v3 L=10u W=0.5u nf=1 ad=0.4p as=0.4p pd=2.6u ps=2.6u m=1
X106 RESETn xpor__RSTB VDD VDD pfet_03v3 L=1u W=1u nf=1 ad=0.8p as=0.8p pd=3.6u ps=3.6u m=1
X107 xtemp__NT xtemp__NT xtemp__NT xtemp__NT pfet_03v3 L=4u W=16u nf=1 ad=12.8p as=12.8p pd=33.6u ps=33.6u m=1
X108 xtemp__N1 xtemp__NA xtemp__NT xtemp__NT pfet_03v3 L=4u W=16u nf=1 ad=12.8p as=12.8p pd=33.6u ps=33.6u m=1
X109 xtemp__N2 xtemp__NB xtemp__NT xtemp__NT pfet_03v3 L=4u W=16u nf=1 ad=12.8p as=12.8p pd=33.6u ps=33.6u m=1
X110 xtemp__N2 xtemp__NB xtemp__NT xtemp__NT pfet_03v3 L=4u W=16u nf=1 ad=12.8p as=12.8p pd=33.6u ps=33.6u m=1
X111 xtemp__N1 xtemp__NA xtemp__NT xtemp__NT pfet_03v3 L=4u W=16u nf=1 ad=12.8p as=12.8p pd=33.6u ps=33.6u m=1
X112 xtemp__NT xtemp__NT xtemp__NT xtemp__NT pfet_03v3 L=4u W=16u nf=1 ad=12.8p as=12.8p pd=33.6u ps=33.6u m=1
X113 xtemp__NT xtemp__PB VDD VDD pfet_03v3 L=4u W=20u nf=1 ad=16p as=16p pd=41.6u ps=41.6u m=1
X114 VDD VDD VDD VDD pfet_03v3 L=4u W=4u nf=1 ad=3.2p as=3.2p pd=9.6u ps=9.6u m=1
X115 xtemp__M1D xtemp__PG VDD VDD pfet_03v3 L=4u W=4u nf=1 ad=3.2p as=3.2p pd=9.6u ps=9.6u m=1
X116 xtemp__NA xtemp__PCAS xtemp__M1D VDD pfet_03v3 L=1u W=4u nf=1 ad=3.2p as=3.2p pd=9.6u ps=9.6u m=1
X117 xtemp__M2D xtemp__PG VDD VDD pfet_03v3 L=4u W=4u nf=1 ad=3.2p as=3.2p pd=9.6u ps=9.6u m=1
X118 xtemp__NB xtemp__PCAS xtemp__M2D VDD pfet_03v3 L=1u W=4u nf=1 ad=3.2p as=3.2p pd=9.6u ps=9.6u m=1
X119 xtemp__M3D xtemp__PG VDD VDD pfet_03v3 L=4u W=4u nf=1 ad=3.2p as=3.2p pd=9.6u ps=9.6u m=1
X120 PTAT xtemp__PCAS xtemp__M3D VDD pfet_03v3 L=1u W=4u nf=1 ad=3.2p as=3.2p pd=9.6u ps=9.6u m=1
X121 PTAT xtemp__PCAS xtemp__M3D VDD pfet_03v3 L=1u W=4u nf=1 ad=3.2p as=3.2p pd=9.6u ps=9.6u m=1
X122 xtemp__M3D xtemp__PG VDD VDD pfet_03v3 L=4u W=4u nf=1 ad=3.2p as=3.2p pd=9.6u ps=9.6u m=1
X123 xtemp__NB xtemp__PCAS xtemp__M2D VDD pfet_03v3 L=1u W=4u nf=1 ad=3.2p as=3.2p pd=9.6u ps=9.6u m=1
X124 xtemp__M2D xtemp__PG VDD VDD pfet_03v3 L=4u W=4u nf=1 ad=3.2p as=3.2p pd=9.6u ps=9.6u m=1
X125 xtemp__NA xtemp__PCAS xtemp__M1D VDD pfet_03v3 L=1u W=4u nf=1 ad=3.2p as=3.2p pd=9.6u ps=9.6u m=1
X126 xtemp__M1D xtemp__PG VDD VDD pfet_03v3 L=4u W=4u nf=1 ad=3.2p as=3.2p pd=9.6u ps=9.6u m=1
X127 VDD VDD VDD VDD pfet_03v3 L=4u W=4u nf=1 ad=3.2p as=3.2p pd=9.6u ps=9.6u m=1
X128 xtemp__PG xtemp__PB VDD VDD pfet_03v3 L=4u W=10u nf=1 ad=8p as=8p pd=21.6u ps=21.6u m=1
X129 xtemp__PB xtemp__PB VDD VDD pfet_03v3 L=4u W=10u nf=1 ad=8p as=8p pd=21.6u ps=21.6u m=1
X130 xtemp__PCAS xtemp__PCAS VDD VDD pfet_03v3 L=8u W=1u nf=1 ad=0.8p as=0.8p pd=3.6u ps=3.6u m=1
X131 xtemp__ENB RESETn VDD VDD pfet_03v3 L=0.5u W=2u nf=1 ad=1.6p as=1.6p pd=5.6u ps=5.6u m=1
X132 xtemp__ND xtemp__PB VDD VDD pfet_03v3 L=8u W=1u nf=1 ad=0.8p as=0.8p pd=3.6u ps=3.6u m=1
X133 xtemp__NR xtemp__PG VDD VDD pfet_03v3 L=4u W=1u nf=1 ad=0.8p as=0.8p pd=3.6u ps=3.6u m=1
X134 xtemp__PG RESETn VDD VDD pfet_03v3 L=0.5u W=4u nf=1 ad=3.2p as=3.2p pd=9.6u ps=9.6u m=1
X135 xcmp__BIAS_OKB BIAS_OK VDD VDD pfet_03v3 L=0.5u W=2u nf=1 ad=1.6p as=1p pd=5.6u ps=5u m=1
X136 VSS VSS xbias__EC pnp_10p00x10p00
X137 VSS VSS xbias__EC pnp_10p00x10p00
X138 VSS VSS xbias__EC pnp_10p00x10p00
X139 VSS VSS xbias__EC pnp_10p00x10p00
X140 VSS VSS xbias__NA pnp_10p00x10p00
X141 VSS VSS xbias__EC pnp_10p00x10p00
X142 VSS VSS xbias__ER pnp_10p00x10p00
X143 VSS VSS xbias__EC pnp_10p00x10p00
X144 VSS VSS xbias__EC pnp_10p00x10p00
X145 VSS VSS xbias__EC pnp_10p00x10p00
X146 VSS VSS xtemp__NC pnp_10p00x10p00
X147 VSS VSS xtemp__NC pnp_10p00x10p00
X148 VSS VSS xtemp__NC pnp_10p00x10p00
X149 VSS VSS xtemp__NC pnp_10p00x10p00
X150 VSS VSS xtemp__NA pnp_10p00x10p00
X151 VSS VSS xtemp__NC pnp_10p00x10p00
X152 VSS VSS xtemp__NC pnp_10p00x10p00
X153 VSS VSS xtemp__NC pnp_10p00x10p00
X154 VSS VSS xtemp__NC pnp_10p00x10p00
X155 xpor__NDG VSS cap_mim_2f0_m3m4_noshield c_width=11u c_length=11u
X156 xpor__TIM VSS cap_mim_2f0_m3m4_noshield c_width=28u c_length=28u
X157 xpor__TIM VSS cap_mim_2f0_m3m4_noshield c_width=28u c_length=28u
X158 VDD xbias__NOKX cap_mim_2f0_m3m4_noshield c_width=6u c_length=6u
X159 xbias__PG xbias__NZ cap_mim_2f0_m3m4_noshield c_width=20u c_length=20u
X160 xpor__TIM VSS cap_mim_2f0_m3m4_noshield c_width=28u c_length=28u
X161 xpor__TIM VSS cap_mim_2f0_m3m4_noshield c_width=28u c_length=28u
X162 xtemp__PG xtemp__NZ cap_mim_2f0_m3m4_noshield c_width=12u c_length=12u
X163 xtemp__NB xtemp__XR1__1 VSS ppolyf_u r_width=2u r_length=59.735u
X164 xtemp__NC xtemp__XR1__1 VSS ppolyf_u r_width=2u r_length=59.735u
X165 xtemp__NA xtemp__XRISO__1 VSS ppolyf_u r_width=2u r_length=55.525u
X166 CTAT xtemp__XRISO__1 VSS ppolyf_u r_width=2u r_length=55.525u
X167 xtemp__NZ xtemp__XRZ__1 VSS ppolyf_u r_width=2u r_length=100u
X168 xtemp__XRZ__2 xtemp__XRZ__1 VSS ppolyf_u r_width=2u r_length=100u
X169 xtemp__XRZ__2 xtemp__XRZ__3 VSS ppolyf_u r_width=2u r_length=100u
X170 xtemp__XRZ__4 xtemp__XRZ__3 VSS ppolyf_u r_width=2u r_length=100u
X171 xtemp__XRZ__4 xtemp__XRZ__5 VSS ppolyf_u r_width=2u r_length=100u
X172 xtemp__XRZ__6 xtemp__XRZ__5 VSS ppolyf_u r_width=2u r_length=100u
X173 xtemp__XRZ__6 xtemp__XRZ__7 VSS ppolyf_u r_width=2u r_length=100u
X174 xtemp__XRZ__8 xtemp__XRZ__7 VSS ppolyf_u r_width=2u r_length=100u
X175 xtemp__XRZ__8 xtemp__XRZ__9 VSS ppolyf_u r_width=2u r_length=100u
X176 xtemp__N2 xtemp__XRZ__9 VSS ppolyf_u r_width=2u r_length=100u
X177 PTAT xtemp__XR2F__1 VSS ppolyf_u r_width=2u r_length=110.525u
X178 xtemp__XR2F__2 xtemp__XR2F__1 VSS ppolyf_u r_width=2u r_length=110.525u
X179 xtemp__XR2F__2 xtemp__XR2F__3 VSS ppolyf_u r_width=2u r_length=110.525u
X180 xtemp__XR2F__4 xtemp__XR2F__3 VSS ppolyf_u r_width=2u r_length=110.525u
X181 xtemp__XR2F__4 xtemp__XR2F__5 VSS ppolyf_u r_width=2u r_length=110.525u
X182 xtemp__XR2F__6 xtemp__XR2F__5 VSS ppolyf_u r_width=2u r_length=110.525u
X183 xtemp__XR2F__6 xtemp__XR2F__7 VSS ppolyf_u r_width=2u r_length=110.525u
X184 xtemp__XR2F__8 xtemp__XR2F__7 VSS ppolyf_u r_width=2u r_length=110.525u
X185 xtemp__XR2F__8 xtemp__XR2F__9 VSS ppolyf_u r_width=2u r_length=110.525u
X186 xtemp__XR2F__10 xtemp__XR2F__9 VSS ppolyf_u r_width=2u r_length=110.525u
X187 xtemp__XR2F__10 xtemp__XR2F__11 VSS ppolyf_u r_width=2u r_length=110.525u
X188 xtemp__XR2F__12 xtemp__XR2F__11 VSS ppolyf_u r_width=2u r_length=110.525u
X189 xtemp__XR2F__12 xtemp__XR2F__13 VSS ppolyf_u r_width=2u r_length=110.525u
X190 xtemp__XR2F__14 xtemp__XR2F__13 VSS ppolyf_u r_width=2u r_length=110.525u
X191 xtemp__XR2F__14 xtemp__XR2F__15 VSS ppolyf_u r_width=2u r_length=110.525u
X192 xtemp__XR2F__16 xtemp__XR2F__15 VSS ppolyf_u r_width=2u r_length=110.525u
X193 xtemp__XR2F__16 xtemp__XR2F__17 VSS ppolyf_u r_width=2u r_length=110.525u
X194 xtemp__XR2F__18 xtemp__XR2F__17 VSS ppolyf_u r_width=2u r_length=110.525u
X195 xtemp__XR2F__18 xtemp__XR2F__19 VSS ppolyf_u r_width=2u r_length=110.525u
X196 xtemp__XR2F__20 xtemp__XR2F__19 VSS ppolyf_u r_width=2u r_length=110.525u
X197 xtemp__XR2F__20 xtemp__XR2F__21 VSS ppolyf_u r_width=2u r_length=110.525u
X198 xtemp__XR2F__22 xtemp__XR2F__21 VSS ppolyf_u r_width=2u r_length=110.525u
X199 xtemp__XR2F__22 xtemp__XR2F__23 VSS ppolyf_u r_width=2u r_length=110.525u
X200 xtemp__T5 xtemp__XR2F__23 VSS ppolyf_u r_width=2u r_length=110.525u
X201 xtemp__T5 xtemp__XR2T5__1 VSS ppolyf_u r_width=2u r_length=114.855u
X202 xtemp__T4 xtemp__XR2T5__1 VSS ppolyf_u r_width=2u r_length=114.855u
X203 xtemp__T4 xtemp__XR2T4__1 VSS ppolyf_u r_width=2u r_length=57.345u
X204 xtemp__T3 xtemp__XR2T4__1 VSS ppolyf_u r_width=2u r_length=57.345u
X205 xtemp__T3 xtemp__XR2T3__1 VSS ppolyf_u r_width=2u r_length=28.59u
X206 xtemp__T2 xtemp__XR2T3__1 VSS ppolyf_u r_width=2u r_length=28.59u
X207 xtemp__T2 xtemp__XR2T2__1 VSS ppolyf_u r_width=2u r_length=14.21u
X208 xtemp__T1 xtemp__XR2T2__1 VSS ppolyf_u r_width=2u r_length=14.21u
X209 xtemp__T1 xtemp__XR2T1__1 VSS ppolyf_u r_width=2u r_length=7.015u
X210 xtemp__T0 xtemp__XR2T1__1 VSS ppolyf_u r_width=2u r_length=7.015u
X211 xtemp__T0 xtemp__XR2T0__1 VSS ppolyf_u r_width=2u r_length=3.425u
X212 VSS xtemp__XR2T0__1 VSS ppolyf_u r_width=2u r_length=3.425u
X213 xcmp__SNS VDD VSS ppolyf_u_3k r_width=2u r_length=7897.44u
X214 xcmp__SNSB xcmp__SNS VSS ppolyf_u_3k r_width=2u r_length=6769.23u
X215 VSS xcmp__SNSB VSS ppolyf_u_3k r_width=2u r_length=775u
X216 VREF xbias__XR2__1 VSS ppolyf_u_3k r_width=2u r_length=256.5u
X217 xbias__XR2__2 xbias__XR2__1 VSS ppolyf_u_3k r_width=2u r_length=256.5u
X218 xbias__XR2__2 xbias__XR2__3 VSS ppolyf_u_3k r_width=2u r_length=256.5u
X219 xbias__XR2__4 xbias__XR2__3 VSS ppolyf_u_3k r_width=2u r_length=256.5u
X220 xbias__XR2__4 xbias__XR2__5 VSS ppolyf_u_3k r_width=2u r_length=256.5u
X221 xbias__XR2__6 xbias__XR2__5 VSS ppolyf_u_3k r_width=2u r_length=256.5u
X222 xbias__XR2__6 xbias__XR2__7 VSS ppolyf_u_3k r_width=2u r_length=256.5u
X223 xbias__XR2__8 xbias__XR2__7 VSS ppolyf_u_3k r_width=2u r_length=256.5u
X224 xbias__XR2__8 xbias__XR2__9 VSS ppolyf_u_3k r_width=2u r_length=256.5u
X225 xbias__XR2__10 xbias__XR2__9 VSS ppolyf_u_3k r_width=2u r_length=256.5u
X226 xbias__XR2__10 xbias__XR2__11 VSS ppolyf_u_3k r_width=2u r_length=256.5u
X227 xbias__XR2__12 xbias__XR2__11 VSS ppolyf_u_3k r_width=2u r_length=256.5u
X228 xbias__XR2__12 xbias__XR2__13 VSS ppolyf_u_3k r_width=2u r_length=256.5u
X229 xbias__XR2__14 xbias__XR2__13 VSS ppolyf_u_3k r_width=2u r_length=256.5u
X230 xbias__XR2__14 xbias__XR2__15 VSS ppolyf_u_3k r_width=2u r_length=256.5u
X231 xbias__ER xbias__XR2__15 VSS ppolyf_u_3k r_width=2u r_length=256.5u
X232 xbias__NZ xbias__XRZ__1 VSS ppolyf_u_3k r_width=2u r_length=254u
X233 xbias__XRZ__2 xbias__XRZ__1 VSS ppolyf_u_3k r_width=2u r_length=254u
X234 xbias__XRZ__2 xbias__XRZ__3 VSS ppolyf_u_3k r_width=2u r_length=254u
X235 xbias__N2 xbias__XRZ__3 VSS ppolyf_u_3k r_width=2u r_length=254u
X236 xbias__NB xbias__XR1__1 VSS ppolyf_u_3k r_width=2u r_length=175u
X237 xbias__EC xbias__XR1__1 VSS ppolyf_u_3k r_width=2u r_length=175u
X238 xbias__NBTOP xbias__XRT__1 VSS ppolyf_u_3k r_width=2u r_length=8.75u
X239 xbias__NB xbias__XRT__1 VSS ppolyf_u_3k r_width=2u r_length=8.75u

R_102 xtemp__XRZ__2 xtemp__XRZ__2__par 50.5749
C_102 xtemp__XRZ__2__par VSS 1.599507e-15
R_103 xtemp__XRZ__4 xtemp__XRZ__4__par 50.5749
C_103 xtemp__XRZ__4__par VSS 1.599507e-15
R_104 xtemp__XRZ__6 xtemp__XRZ__6__par 50.5749
C_104 xtemp__XRZ__6__par VSS 1.599507e-15
R_105 xtemp__XRZ__8 xtemp__XRZ__8__par 50.5749
C_105 xtemp__XRZ__8__par VSS 1.599507e-15
R_106 xtemp__XR2F__2 xtemp__XR2F__2__par 50.5749
C_106 xtemp__XR2F__2__par VSS 1.599507e-15
R_107 xtemp__XR2F__4 xtemp__XR2F__4__par 50.5749
C_107 xtemp__XR2F__4__par VSS 1.599507e-15
R_108 xtemp__XR2F__6 xtemp__XR2F__6__par 50.5749
C_108 xtemp__XR2F__6__par VSS 1.599507e-15
R_109 xtemp__XR2F__8 xtemp__XR2F__8__par 50.5749
C_109 xtemp__XR2F__8__par VSS 1.599507e-15
R_11 xbias__NT xbias__NT__par 4684.5858
C_11 xbias__NT__par VSS 4.9951788e-14
R_110 xtemp__XR2F__10 xtemp__XR2F__10__par 50.5749
C_110 xtemp__XR2F__10__par VSS 1.599507e-15
R_111 xtemp__XR2F__12 xtemp__XR2F__12__par 50.5749
C_111 xtemp__XR2F__12__par VSS 1.599507e-15
R_112 xtemp__XR2F__14 xtemp__XR2F__14__par 50.5749
C_112 xtemp__XR2F__14__par VSS 1.599507e-15
R_113 xtemp__XR2F__16 xtemp__XR2F__16__par 50.5749
C_113 xtemp__XR2F__16__par VSS 1.599507e-15
R_114 xtemp__XR2F__18 xtemp__XR2F__18__par 50.5749
C_114 xtemp__XR2F__18__par VSS 1.599507e-15
R_115 xtemp__XR2F__20 xtemp__XR2F__20__par 50.5749
C_115 xtemp__XR2F__20__par VSS 1.599507e-15
R_116 xtemp__XR2F__22 xtemp__XR2F__22__par 50.5749
C_116 xtemp__XR2F__22__par VSS 1.599507e-15
R_12 xbias__N1 xbias__N1__par 4967.8583
C_12 xbias__N1__par VSS 5.978126e-14
R_122 xtemp__XR2T0__1 xtemp__XR2T0__1__par 50.5749
C_122 xtemp__XR2T0__1__par VSS 1.599507e-15
R_123 xtemp__XR2T1__1 xtemp__XR2T1__1__par 50.5749
C_123 xtemp__XR2T1__1__par VSS 1.599507e-15
R_128 xtemp__XR2T2__1 xtemp__XR2T2__1__par 50.5749
C_128 xtemp__XR2T2__1__par VSS 1.599507e-15
R_13 xbias__N2 xbias__N2__par 7855.0506
C_13 xbias__N2__par VSS 8.4779094e-14
R_132 xtemp__XR2T3__1 xtemp__XR2T3__1__par 50.5749
C_132 xtemp__XR2T3__1__par VSS 1.599507e-15
R_14 xbias__TOK xbias__TOK__par 4690.5254
C_14 xbias__TOK__par VSS 5.2350545e-14
R_140 xtemp__XRISO__1 xtemp__XRISO__1__par 50.5749
C_140 xtemp__XRISO__1__par VSS 1.599507e-15
R_141 xtemp__XR2T4__1 xtemp__XR2T4__1__par 50.5749
C_141 xtemp__XR2T4__1__par VSS 1.599507e-15
R_142 xtemp__XR1__1 xtemp__XR1__1__par 50.5749
C_142 xtemp__XR1__1__par VSS 1.599507e-15
R_143 xtemp__XRZ__1 xtemp__XRZ__1__par 50.5749
C_143 xtemp__XRZ__1__par VSS 1.599507e-15
R_144 xtemp__XRZ__3 xtemp__XRZ__3__par 50.5749
C_144 xtemp__XRZ__3__par VSS 1.599507e-15
R_145 xtemp__XRZ__5 xtemp__XRZ__5__par 50.5749
C_145 xtemp__XRZ__5__par VSS 1.599507e-15
R_146 xtemp__XRZ__7 xtemp__XRZ__7__par 50.5749
C_146 xtemp__XRZ__7__par VSS 1.599507e-15
R_147 xtemp__XRZ__9 xtemp__XRZ__9__par 50.5749
C_147 xtemp__XRZ__9__par VSS 1.599507e-15
R_148 xtemp__XR2F__1 xtemp__XR2F__1__par 50.5749
C_148 xtemp__XR2F__1__par VSS 1.599507e-15
R_149 xtemp__XR2F__3 xtemp__XR2F__3__par 50.5749
C_149 xtemp__XR2F__3__par VSS 1.599507e-15
R_15 xbias__NOKO xbias__NOKO__par 4792.4183
C_15 xbias__NOKO__par VSS 5.9161863e-14
R_150 xtemp__XR2F__5 xtemp__XR2F__5__par 50.5749
C_150 xtemp__XR2F__5__par VSS 1.599507e-15
R_151 xtemp__XR2F__7 xtemp__XR2F__7__par 50.5749
C_151 xtemp__XR2F__7__par VSS 1.599507e-15
R_152 xtemp__XR2F__9 xtemp__XR2F__9__par 50.5749
C_152 xtemp__XR2F__9__par VSS 1.599507e-15
R_153 xtemp__XR2F__11 xtemp__XR2F__11__par 50.5749
C_153 xtemp__XR2F__11__par VSS 1.599507e-15
R_154 xtemp__XR2F__13 xtemp__XR2F__13__par 50.5749
C_154 xtemp__XR2F__13__par VSS 1.599507e-15
R_155 xtemp__XR2F__15 xtemp__XR2F__15__par 50.5749
C_155 xtemp__XR2F__15__par VSS 1.599507e-15
R_156 xtemp__XR2F__17 xtemp__XR2F__17__par 50.5749
C_156 xtemp__XR2F__17__par VSS 1.599507e-15
R_157 xtemp__XR2F__19 xtemp__XR2F__19__par 50.5749
C_157 xtemp__XR2F__19__par VSS 1.599507e-15
R_158 xtemp__XR2F__21 xtemp__XR2F__21__par 50.5749
C_158 xtemp__XR2F__21__par VSS 1.599507e-15
R_159 xtemp__XR2F__23 xtemp__XR2F__23__par 50.5749
C_159 xtemp__XR2F__23__par VSS 1.599507e-15
R_16 xbias__NOKL xbias__NOKL__par 4883.997
C_16 xbias__NOKL__par VSS 6.0794305e-14
R_160 xtemp__XR2T5__1 xtemp__XR2T5__1__par 50.5749
C_160 xtemp__XR2T5__1__par VSS 1.599507e-15
R_17 xbias__NKG xbias__NKG__par 4848.0503
C_17 xbias__NKG__par VSS 5.7785044e-14
R_18 xbias__NB xbias__NB__par 7667.0394
C_18 xbias__NB__par VSS 7.6118691e-14
R_19 xcmp__VDDA xcmp__VDDA__par 1263.8244
C_19 xcmp__VDDA__par VSS 1.4679011e-14
R_20 xcmp__NA xcmp__NA__par 1384.846
C_20 xcmp__NA__par VSS 1.5868526e-14
R_21 xcmp__CMPO xcmp__CMPO__par 1382.1249
C_21 xcmp__CMPO__par VSS 1.7766709e-14
R_23 xcmp__N1 xcmp__N1__par 1437.8825
C_23 xcmp__N1__par VSS 1.7866109e-14
R_24 xcmp__TN xcmp__TN__par 1261.1261
C_24 xcmp__TN__par VSS 1.3588667e-14
R_25 xcmp__SNS xcmp__SNS__par 1410.6865
C_25 xcmp__SNS__par VSS 2.5945833e-14
R_26 xcmp__NBG xcmp__NBG__par 1516.9554
C_26 xcmp__NBG__par VSS 2.1326008e-14
R_27 xcmp__SNSB xcmp__SNSB__par 1330.8009
C_27 xcmp__SNSB__par VSS 1.7531363e-14
R_28 xpor__PDN xpor__PDN__par 4872.4842
C_28 xpor__PDN__par VSS 5.6528747e-14
R_29 xpor__NDL xpor__NDL__par 4462.4943
C_29 xpor__NDL__par VSS 4.7374149e-14
R_30 xpor__NDGN xpor__NDGN__par 3937.0807
C_30 xpor__NDGN__par VSS 3.4262384e-14
R_31 xpor__PGDG xpor__PGDG__par 4189.4235
C_31 xpor__PGDG__par VSS 4.2346747e-14
R_32 xpor__PGDGB xpor__PGDGB__par 4066.8737
C_32 xpor__PGDGB__par VSS 3.8945287e-14
R_33 xpor__ND1 xpor__ND1__par 4009.3517
C_33 xpor__ND1__par VSS 3.9540693e-14
R_34 xpor__NNAND xpor__NNAND__par 3939.9598
C_34 xpor__NNAND__par VSS 3.5425418e-14
R_35 xpor__NDGP xpor__NDGP__par 3936.7209
C_35 xpor__NDGP__par VSS 3.4117005e-14
R_36 xpor__NTS xpor__NTS__par 3938.5314
C_36 xpor__NTS__par VSS 3.4848444e-14
R_37 xpor__RSTB xpor__RSTB__par 4076.1772
C_37 xpor__RSTB__par VSS 4.4255369e-14
R_39 xbias__NKM xbias__NKM__par 4876.8874
C_39 xbias__NKM__par VSS 5.7923066e-14
R_40 xbias__NOKX xbias__NOKX__par 4848.8283
C_40 xbias__NOKX__par VSS 5.9899291e-14
R_41 xbias__KS1 xbias__KS1__par 4818.8511
C_41 xbias__KS1__par VSS 5.4330567e-14
R_42 xbias__KS2 xbias__KS2__par 4819.3911
C_42 xbias__KS2__par VSS 5.4548635e-14
R_43 xbias__KS3 xbias__KS3__par 4819.931
C_43 xbias__KS3__par VSS 5.4766704e-14
R_44 xbias__KS4 xbias__KS4__par 4820.471
C_44 xbias__KS4__par VSS 5.4984773e-14
R_45 xbias__NZ xbias__NZ__par 2787.6635
C_45 xbias__NZ__par VSS 2.5602753e-14
R_46 xbias__EC xbias__EC__par 2791.7858
C_46 xbias__EC__par VSS 7.4268842e-14
R_47 xpor__NDG xpor__NDG__par 4070.5407
C_47 xpor__NDG__par VSS 3.8729499e-14
R_48 xpor__TIM xpor__TIM__par 4003.8986
C_48 xpor__TIM__par VSS 3.7357712e-14
R_49 xpor__TRIP xpor__TRIP__par 4060.1906
C_49 xpor__TRIP__par VSS 3.9480796e-14
R_54 xbias__XR2__2 xbias__XR2__2__par 18.25
C_54 xbias__XR2__2__par VSS 1.8067e-15
R_55 xbias__XR2__4 xbias__XR2__4__par 18.25
C_55 xbias__XR2__4__par VSS 1.8067e-15
R_56 xbias__XR2__6 xbias__XR2__6__par 18.25
C_56 xbias__XR2__6__par VSS 1.8067e-15
R_57 xbias__XR2__8 xbias__XR2__8__par 18.25
C_57 xbias__XR2__8__par VSS 1.8067e-15
R_58 xbias__XR2__10 xbias__XR2__10__par 18.25
C_58 xbias__XR2__10__par VSS 1.8067e-15
R_59 xbias__XR2__12 xbias__XR2__12__par 18.25
C_59 xbias__XR2__12__par VSS 1.8067e-15
R_6 xbias__PG xbias__PG__par 5084.4335
C_6 xbias__PG__par VSS 6.829458e-14
R_60 xbias__XR2__14 xbias__XR2__14__par 18.25
C_60 xbias__XR2__14__par VSS 1.8067e-15
R_61 xbias__XRZ__2 xbias__XRZ__2__par 18.25
C_61 xbias__XRZ__2__par VSS 1.8067e-15
R_62 xbias__XRT__1 xbias__XRT__1__par 18.25
C_62 xbias__XRT__1__par VSS 1.8067e-15
R_63 xbias__NA xbias__NA__par 8008.5898
C_63 xbias__NA__par VSS 8.7590412e-14
R_64 xbias__ER xbias__ER__par 2787.674
C_64 xbias__ER__par VSS 3.3170077e-14
R_66 xbias__XRZ__1 xbias__XRZ__1__par 18.25
C_66 xbias__XRZ__1__par VSS 1.8067e-15
R_67 xbias__XRZ__3 xbias__XRZ__3__par 18.25
C_67 xbias__XRZ__3__par VSS 1.8067e-15
R_68 xbias__XR1__1 xbias__XR1__1__par 18.25
C_68 xbias__XR1__1__par VSS 1.8067e-15
R_69 xbias__XR2__13 xbias__XR2__13__par 18.25
C_69 xbias__XR2__13__par VSS 1.8067e-15
R_7 xbias__NBTOP xbias__NBTOP__par 7796.7657
C_7 xbias__NBTOP__par VSS 7.8325844e-14
R_70 xbias__XR2__11 xbias__XR2__11__par 18.25
C_70 xbias__XR2__11__par VSS 1.8067e-15
R_71 xbias__XR2__1 xbias__XR2__1__par 18.25
C_71 xbias__XR2__1__par VSS 1.8067e-15
R_72 xbias__XR2__3 xbias__XR2__3__par 18.25
C_72 xbias__XR2__3__par VSS 1.8067e-15
R_73 xbias__XR2__5 xbias__XR2__5__par 18.25
C_73 xbias__XR2__5__par VSS 1.8067e-15
R_74 xbias__XR2__7 xbias__XR2__7__par 18.25
C_74 xbias__XR2__7__par VSS 1.8067e-15
R_75 xbias__XR2__9 xbias__XR2__9__par 18.25
C_75 xbias__XR2__9__par VSS 1.8067e-15
R_76 xbias__XR2__15 xbias__XR2__15__par 18.25
C_76 xbias__XR2__15__par VSS 1.8067e-15
R_8 xbias__NBG xbias__NBG__par 4871.7578
C_8 xbias__NBG__par VSS 5.5851412e-14
R_9 xbias__PB xbias__PB__par 5396.0003
C_9 xbias__PB__par VSS 7.9168117e-14
RBIAS_OK BIAS_OK BIAS_OK__par 6145.4389
CBIAS_OK BIAS_OK__par VSS 6.2768673e-14
RBIAS_OKB xcmp__BIAS_OKB xcmp__BIAS_OKB__par 1631.1837
CBIAS_OKB xcmp__BIAS_OKB__par VSS 2.1659338e-14
RCTAT CTAT CTAT__par 508.901
CCTAT CTAT__par VSS 3.2409351e-14
REN_RESETn RESETn RESETn__par 5644.0621
CEN_RESETn RESETn__par VSS 7.8040539e-14
RENB xtemp__ENB xtemp__ENB__par 1722.3174
CENB xtemp__ENB__par VSS 3.6434644e-14
RIBIAS IBIAS IBIAS__par 10641.6413
CIBIAS IBIAS__par VSS 1.22603459e-13
RM1D xtemp__M1D xtemp__M1D__par 1326.5002
CM1D xtemp__M1D__par VSS 2.6584926e-14
RM2D xtemp__M2D xtemp__M2D__par 1250.9542
CM2D xtemp__M2D__par VSS 2.5194004e-14
RM3D xtemp__M3D xtemp__M3D__par 1175.4138
CM3D xtemp__M3D__par VSS 2.3803081e-14
RN1 xtemp__N1 xtemp__N1__par 3916.0744
CN1 xtemp__N1__par VSS 3.9166451e-14
RN2 xtemp__N2 xtemp__N2__par 2349.712
CN2 xtemp__N2__par VSS 5.2203575e-14
RNA xtemp__NA xtemp__NA__par 2133.218
CNA xtemp__NA__par VSS 6.3089263e-14
RNB xtemp__NB xtemp__NB__par 2057.3709
CNB xtemp__NB__par VSS 4.3487422e-14
RNBG xtemp__NBG xtemp__NBG__par 1144.9314
CNBG xtemp__NBG__par VSS 2.6946068e-14
RNC xtemp__NC xtemp__NC__par 65.9407
CNC xtemp__NC__par VSS 8.5417204e-14
RND xtemp__ND xtemp__ND__par 1512.6715
CND xtemp__ND__par VSS 3.4769335e-14
RNR xtemp__NR xtemp__NR__par 1694.9168
CNR xtemp__NR__par VSS 3.5399052e-14
RNT xtemp__NT xtemp__NT__par 5451.5605
CNT xtemp__NT__par VSS 7.8898189e-14
RNZ xtemp__NZ xtemp__NZ__par 105.4766
CNZ xtemp__NZ__par VSS 2.9335487e-14
RPB xtemp__PB xtemp__PB__par 3535.6753
CPB xtemp__PB__par VSS 4.7145745e-14
RPCAS xtemp__PCAS xtemp__PCAS__par 4548.8647
CPCAS xtemp__PCAS__par VSS 5.3738496e-14
RPG xtemp__PG xtemp__PG__par 5100.563
CPG xtemp__PG__par VSS 6.1728862e-14
RPOR_RAW POR_RAW POR_RAW__par 5322.6333
CPOR_RAW POR_RAW__par VSS 4.7741177e-14
RPTAT PTAT PTAT__par 962.4337
CPTAT PTAT__par VSS 3.9542032e-14
RT0 xtemp__T0 xtemp__T0__par 1253.0071
CT0 xtemp__T0__par VSS 5.5998739e-14
RT1 xtemp__T1 xtemp__T1__par 1214.9021
CT1 xtemp__T1__par VSS 5.5179431e-14
RT2 xtemp__T2 xtemp__T2__par 1176.8024
CT2 xtemp__T2__par VSS 5.4360123e-14
RT3 xtemp__T3 xtemp__T3__par 1138.7083
CT3 xtemp__T3__par VSS 5.3540815e-14
RT4 xtemp__T4 xtemp__T4__par 1100.6204
CT4 xtemp__T4__par VSS 5.2721507e-14
RT5 xtemp__T5 xtemp__T5__par 607.3914
CT5 xtemp__T5__par VSS 4.5515196e-14
RVDD VDD VDD__par 12219.9609
CVDD VDD__par VSS 3.93566639e-13
RVREF VREF VREF__par 9024.0306
CVREF VREF__par VSS 8.5089816e-14
RVSS VSS VSS__par 3386.9482
CVSS VSS__par VSS 1.829144318e-12
.ends temp_por_top
