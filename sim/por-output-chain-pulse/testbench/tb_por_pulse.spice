* tb_por_pulse -- GENERATED by sim/build_tb.py
* Do not edit. Sources:
*   sim/por-output-chain-pulse/testbench/stimulus.spice
*   design/netlist/por_output_chain.spice  (sha256 f71217cddbbdd31985e4c8f89cc77717a77e514723ce437e8fed7e80931c9817)
* Regenerate with:
*   python3 sim/build_tb.py

* por-output-chain-pulse -- stimulus half of the testbench fragment.
*
* The other half is a verbatim copy of design/netlist/por_output_chain.spice,
* appended by sim/build_tb.py to produce tb_por_pulse.spice. Edit THIS file
* (or the schematic), never the generated fragment.
*
* Netlist FRAGMENT: no .include / .lib / .temp / .control / .end -- the
* harness owns those. Parameters it supplies: vdd_val, vdd_nom, temp_c.
*
* WHAT THIS EXPERIMENT SUBSTANTIATES
*
* spec/target-spec.md#por-reset-pulse: RESETn stays asserted for >=1 ms after
* the release conditions are met, at the FASTEST-timer corner. The pulse here
* is a current-starved ramp (2.5 nA into 6.27 pF), so "fastest" is the corner
* with the most charging current and the least capacitance -- FF / +125 C /
* 3.63 V -- and the whole 81-point grid is swept to prove that is really where
* the minimum lands rather than assuming it.
*
* It also records this cell's share of the shared spec/target-spec.md#por-iq
* budget, sampled in the state that row is defined in (rule 1 of the table's
* section 5): RESETn asserted, rail settled, sensor disabled.
*
* THE IBIAS TOLERANCE PROBLEM, AND WHY THERE ARE TWO DUTS
*
* Every internal current in this cell is a ratio of IBIAS, so the pulse width
* scales as 1/IBIAS. bias_core (#11) has not landed, so its corner spread is
* not yet knowable; asserting >=1 ms against one ideal 0.5 uA source would be
* a result that #11 could silently invalidate later. Instead two identical
* DUTs run side by side on the same rail:
*
*   xdut1  IBIAS = 0.5 uA   the DR-005 nominal (same convention as temp_core:
*                           bias_core SOURCES the current into the pin)
*   xdut2  IBIAS = 1.5 uA   3x nominal -- the stress case for the >=1 ms
*                           minimum, since more bias current means a faster
*                           timer. If xdut2 clears 1 ms at every corner then
*                           the claim survives a 3x IBIAS error from #11.
*
* TIMELINE
*
*   0     -> 100 us   VDD ramps 0 -> vdd_val (~33 kV/s, inside the ratified
*                     por-ramp-rate envelope). POR_RAW held low.
*   100 us-> 1 ms     rail settled, POR_RAW low: this is exactly the por-iq
*                     accounting state. Sampled at 0.9 ms.
*   1.001 ms          POR_RAW steps high -- the release condition. Stepping it
*                     rather than deriving it from the ramp is deliberate: the
*                     pulse is measured from a single unambiguous t0, and
*                     ramp-crossing behaviour is #14's job, not this record's.
*   ...               RESETn must stay low for >=1 ms, then release once.
*   19.5 ms           released-state draw sampled (feeds iq-total, not por-iq)

vsup vdd 0 PWL(0 0 100u {vdd_val} 20m {vdd_val})
vpr  por_raw 0 PWL(0 0 1m 0 1.002m {vdd_val} 20m {vdd_val})

* IBIAS references. Modelled as coming up with the rail rather than as ideal
* DC sources: below ~1.5 V there is no bias core yet (DR-005 startup ordering
* step 3), so forcing current into the pin while the rail is dead would be a
* stimulus artefact. Same construction as sim/temp-core-startup/.
Bib1 vdd nib1 i='500n*min(1, max(0, (v(vdd)-1.5)/0.5))'
vib1 nib1 ibias1 dc 0
Bib2 vdd nib2 i='1500n*min(1, max(0, (v(vdd)-1.5)/0.5))'
vib2 nib2 ibias2 dc 0

* 0 V ammeters in each DUT's own VDD pin. The IBIAS reference is sourced from
* vdd directly, so it does NOT pass through these -- i(vd1) is what this cell
* draws from the rail on its own account, which is the number the por-iq
* budget needs.
vd1 vdd vdd1 dc 0
vd2 vdd vdd2 dc 0

* por-reset-pulse measurement load, provisional per the spec row: 5 pF, no DC
* load. The 1 Tohm is a solver aid, not a load.
Cl1 resetn1 0 5p
Rl1 resetn1 0 1T
Cl2 resetn2 0 5p
Rl2 resetn2 0 1T

xdut1 vdd1 0 ibias1 por_raw resetn1 por_output_chain
xdut2 vdd2 0 ibias2 por_raw resetn2 por_output_chain

* por_output_chain -- generated by design/netlist.py from design/por_output_chain.sch
* Do not edit: edit the schematic and re-run the export.
** sch_path: design/por_output_chain.sch
.subckt por_output_chain VDD VSS IBIAS POR_RAW RESETn
*.PININFO VDD:B VSS:B IBIAS:I POR_RAW:I RESETn:O
XMBD IBIAS IBIAS VSS VSS nfet_03v3 L=4u W=4u nf=1 ad='int((nf+1)/2) * W/nf * 0.18u' as='int((nf+2)/2) * W/nf * 0.18u' pd='2*int((nf+1)/2) * (W/nf + 0.18u)'
+ ps='2*int((nf+2)/2) * (W/nf + 0.18u)' nrd='0.18u / W' nrs='0.18u / W' sa=0 sb=0 sd=0 m=1
XMN1 PDN IBIAS VSS VSS nfet_03v3 L=25u W=0.5u nf=1 ad='int((nf+1)/2) * W/nf * 0.18u' as='int((nf+2)/2) * W/nf * 0.18u' pd='2*int((nf+1)/2) * (W/nf + 0.18u)'
+ ps='2*int((nf+2)/2) * (W/nf + 0.18u)' nrd='0.18u / W' nrs='0.18u / W' sa=0 sb=0 sd=0 m=1
XMPD PDN PDN VDD VDD pfet_03v3 L=10u W=2u nf=1 ad='int((nf+1)/2) * W/nf * 0.18u' as='int((nf+2)/2) * W/nf * 0.18u' pd='2*int((nf+1)/2) * (W/nf + 0.18u)'
+ ps='2*int((nf+2)/2) * (W/nf + 0.18u)' nrd='0.18u / W' nrs='0.18u / W' sa=0 sb=0 sd=0 m=1
XMP2 NDL PDN VDD VDD pfet_03v3 L=10u W=2u nf=1 ad='int((nf+1)/2) * W/nf * 0.18u' as='int((nf+2)/2) * W/nf * 0.18u' pd='2*int((nf+1)/2) * (W/nf + 0.18u)'
+ ps='2*int((nf+2)/2) * (W/nf + 0.18u)' nrd='0.18u / W' nrs='0.18u / W' sa=0 sb=0 sd=0 m=1
XMND NDL NDL VSS VSS nfet_03v3 L=10u W=2u nf=1 ad='int((nf+1)/2) * W/nf * 0.18u' as='int((nf+2)/2) * W/nf * 0.18u' pd='2*int((nf+1)/2) * (W/nf + 0.18u)'
+ ps='2*int((nf+2)/2) * (W/nf + 0.18u)' nrd='0.18u / W' nrs='0.18u / W' sa=0 sb=0 sd=0 m=1
XMDGPT NDGP PDN VDD VDD pfet_03v3 L=10u W=10u nf=1 ad='int((nf+1)/2) * W/nf * 0.18u' as='int((nf+2)/2) * W/nf * 0.18u' pd='2*int((nf+1)/2) * (W/nf + 0.18u)'
+ ps='2*int((nf+2)/2) * (W/nf + 0.18u)' nrd='0.18u / W' nrs='0.18u / W' sa=0 sb=0 sd=0 m=1
XMDGPI NDG POR_RAW NDGP VDD pfet_03v3 L=0.5u W=1u nf=1 ad='int((nf+1)/2) * W/nf * 0.18u' as='int((nf+2)/2) * W/nf * 0.18u' pd='2*int((nf+1)/2) * (W/nf + 0.18u)'
+ ps='2*int((nf+2)/2) * (W/nf + 0.18u)' nrd='0.18u / W' nrs='0.18u / W' sa=0 sb=0 sd=0 m=1
XMDGNI NDG POR_RAW NDGN VSS nfet_03v3 L=0.5u W=1u nf=1 ad='int((nf+1)/2) * W/nf * 0.18u' as='int((nf+2)/2) * W/nf * 0.18u' pd='2*int((nf+1)/2) * (W/nf + 0.18u)'
+ ps='2*int((nf+2)/2) * (W/nf + 0.18u)' nrd='0.18u / W' nrs='0.18u / W' sa=0 sb=0 sd=0 m=1
XMDGNT NDGN NDL VSS VSS nfet_03v3 L=10u W=10u nf=1 ad='int((nf+1)/2) * W/nf * 0.18u' as='int((nf+2)/2) * W/nf * 0.18u' pd='2*int((nf+1)/2) * (W/nf + 0.18u)'
+ ps='2*int((nf+2)/2) * (W/nf + 0.18u)' nrd='0.18u / W' nrs='0.18u / W' sa=0 sb=0 sd=0 m=1
XCDG NDG VSS cap_mim_2f0_m3m4_noshield c_width=11u c_length=11u m=1
XMG1P PGDG NDG VDD VDD pfet_03v3 L=2u W=0.5u nf=1 ad='int((nf+1)/2) * W/nf * 0.18u' as='int((nf+2)/2) * W/nf * 0.18u' pd='2*int((nf+1)/2) * (W/nf + 0.18u)'
+ ps='2*int((nf+2)/2) * (W/nf + 0.18u)' nrd='0.18u / W' nrs='0.18u / W' sa=0 sb=0 sd=0 m=1
XMG1N PGDG NDG VSS VSS nfet_03v3 L=0.5u W=2u nf=1 ad='int((nf+1)/2) * W/nf * 0.18u' as='int((nf+2)/2) * W/nf * 0.18u' pd='2*int((nf+1)/2) * (W/nf + 0.18u)'
+ ps='2*int((nf+2)/2) * (W/nf + 0.18u)' nrd='0.18u / W' nrs='0.18u / W' sa=0 sb=0 sd=0 m=1
XMG2P PGDGB PGDG VDD VDD pfet_03v3 L=0.5u W=2u nf=1 ad='int((nf+1)/2) * W/nf * 0.18u' as='int((nf+2)/2) * W/nf * 0.18u' pd='2*int((nf+1)/2) * (W/nf + 0.18u)'
+ ps='2*int((nf+2)/2) * (W/nf + 0.18u)' nrd='0.18u / W' nrs='0.18u / W' sa=0 sb=0 sd=0 m=1
XMG2N PGDGB PGDG VSS VSS nfet_03v3 L=2u W=0.5u nf=1 ad='int((nf+1)/2) * W/nf * 0.18u' as='int((nf+2)/2) * W/nf * 0.18u' pd='2*int((nf+1)/2) * (W/nf + 0.18u)'
+ ps='2*int((nf+2)/2) * (W/nf + 0.18u)' nrd='0.18u / W' nrs='0.18u / W' sa=0 sb=0 sd=0 m=1
XMPT NTS PDN VDD VDD pfet_03v3 L=10u W=0.5u nf=1 ad='int((nf+1)/2) * W/nf * 0.18u' as='int((nf+2)/2) * W/nf * 0.18u' pd='2*int((nf+1)/2) * (W/nf + 0.18u)'
+ ps='2*int((nf+2)/2) * (W/nf + 0.18u)' nrd='0.18u / W' nrs='0.18u / W' sa=0 sb=0 sd=0 m=1
XMTSW TIM PGDGB NTS VDD pfet_03v3 L=1u W=2u nf=1 ad='int((nf+1)/2) * W/nf * 0.18u' as='int((nf+2)/2) * W/nf * 0.18u' pd='2*int((nf+1)/2) * (W/nf + 0.18u)'
+ ps='2*int((nf+2)/2) * (W/nf + 0.18u)' nrd='0.18u / W' nrs='0.18u / W' sa=0 sb=0 sd=0 m=1
XMDIS TIM PGDGB VSS VSS nfet_03v3 L=1u W=1u nf=1 ad='int((nf+1)/2) * W/nf * 0.18u' as='int((nf+2)/2) * W/nf * 0.18u' pd='2*int((nf+1)/2) * (W/nf + 0.18u)'
+ ps='2*int((nf+2)/2) * (W/nf + 0.18u)' nrd='0.18u / W' nrs='0.18u / W' sa=0 sb=0 sd=0 m=1
XCTIM TIM VSS cap_mim_2f0_m3m4_noshield c_width=28u c_length=28u m=4
XMDAPI ND1 TIM VDD VDD pfet_03v3 L=1u W=2u nf=1 ad='int((nf+1)/2) * W/nf * 0.18u' as='int((nf+2)/2) * W/nf * 0.18u' pd='2*int((nf+1)/2) * (W/nf + 0.18u)'
+ ps='2*int((nf+2)/2) * (W/nf + 0.18u)' nrd='0.18u / W' nrs='0.18u / W' sa=0 sb=0 sd=0 m=1
XMDANT ND1 NDL VSS VSS nfet_03v3 L=10u W=0.5u nf=1 ad='int((nf+1)/2) * W/nf * 0.18u' as='int((nf+2)/2) * W/nf * 0.18u' pd='2*int((nf+1)/2) * (W/nf + 0.18u)'
+ ps='2*int((nf+2)/2) * (W/nf + 0.18u)' nrd='0.18u / W' nrs='0.18u / W' sa=0 sb=0 sd=0 m=1
XMDBNI TRIP ND1 VSS VSS nfet_03v3 L=1u W=1u nf=1 ad='int((nf+1)/2) * W/nf * 0.18u' as='int((nf+2)/2) * W/nf * 0.18u' pd='2*int((nf+1)/2) * (W/nf + 0.18u)'
+ ps='2*int((nf+2)/2) * (W/nf + 0.18u)' nrd='0.18u / W' nrs='0.18u / W' sa=0 sb=0 sd=0 m=1
XMDBPT TRIP PDN VDD VDD pfet_03v3 L=10u W=0.5u nf=1 ad='int((nf+1)/2) * W/nf * 0.18u' as='int((nf+2)/2) * W/nf * 0.18u' pd='2*int((nf+1)/2) * (W/nf + 0.18u)'
+ ps='2*int((nf+2)/2) * (W/nf + 0.18u)' nrd='0.18u / W' nrs='0.18u / W' sa=0 sb=0 sd=0 m=1
XMRLK ND1 RESETn VSS VSS nfet_03v3 L=1u W=1u nf=1 ad='int((nf+1)/2) * W/nf * 0.18u' as='int((nf+2)/2) * W/nf * 0.18u' pd='2*int((nf+1)/2) * (W/nf + 0.18u)'
+ ps='2*int((nf+2)/2) * (W/nf + 0.18u)' nrd='0.18u / W' nrs='0.18u / W' sa=0 sb=0 sd=0 m=1
XMNAP1 RSTB TRIP VDD VDD pfet_03v3 L=0.5u W=4u nf=1 ad='int((nf+1)/2) * W/nf * 0.18u' as='int((nf+2)/2) * W/nf * 0.18u' pd='2*int((nf+1)/2) * (W/nf + 0.18u)'
+ ps='2*int((nf+2)/2) * (W/nf + 0.18u)' nrd='0.18u / W' nrs='0.18u / W' sa=0 sb=0 sd=0 m=1
XMNAP2 RSTB PGDG VDD VDD pfet_03v3 L=0.5u W=4u nf=1 ad='int((nf+1)/2) * W/nf * 0.18u' as='int((nf+2)/2) * W/nf * 0.18u' pd='2*int((nf+1)/2) * (W/nf + 0.18u)'
+ ps='2*int((nf+2)/2) * (W/nf + 0.18u)' nrd='0.18u / W' nrs='0.18u / W' sa=0 sb=0 sd=0 m=1
XMNAN1 RSTB TRIP NNAND VSS nfet_03v3 L=0.5u W=2u nf=1 ad='int((nf+1)/2) * W/nf * 0.18u' as='int((nf+2)/2) * W/nf * 0.18u' pd='2*int((nf+1)/2) * (W/nf + 0.18u)'
+ ps='2*int((nf+2)/2) * (W/nf + 0.18u)' nrd='0.18u / W' nrs='0.18u / W' sa=0 sb=0 sd=0 m=1
XMNAN2 NNAND PGDG VSS VSS nfet_03v3 L=0.5u W=2u nf=1 ad='int((nf+1)/2) * W/nf * 0.18u' as='int((nf+2)/2) * W/nf * 0.18u' pd='2*int((nf+1)/2) * (W/nf + 0.18u)'
+ ps='2*int((nf+2)/2) * (W/nf + 0.18u)' nrd='0.18u / W' nrs='0.18u / W' sa=0 sb=0 sd=0 m=1
XMAST RSTB RESETn VDD VDD pfet_03v3 L=10u W=0.5u nf=1 ad='int((nf+1)/2) * W/nf * 0.18u' as='int((nf+2)/2) * W/nf * 0.18u' pd='2*int((nf+1)/2) * (W/nf + 0.18u)'
+ ps='2*int((nf+2)/2) * (W/nf + 0.18u)' nrd='0.18u / W' nrs='0.18u / W' sa=0 sb=0 sd=0 m=1
XMOP RESETn RSTB VDD VDD pfet_03v3 L=1u W=1u nf=1 ad='int((nf+1)/2) * W/nf * 0.18u' as='int((nf+2)/2) * W/nf * 0.18u' pd='2*int((nf+1)/2) * (W/nf + 0.18u)'
+ ps='2*int((nf+2)/2) * (W/nf + 0.18u)' nrd='0.18u / W' nrs='0.18u / W' sa=0 sb=0 sd=0 m=1
XMON RESETn RSTB VSS VSS nfet_03v3 L=0.5u W=10u nf=1 ad='int((nf+1)/2) * W/nf * 0.18u' as='int((nf+2)/2) * W/nf * 0.18u' pd='2*int((nf+1)/2) * (W/nf + 0.18u)'
+ ps='2*int((nf+2)/2) * (W/nf + 0.18u)' nrd='0.18u / W' nrs='0.18u / W' sa=0 sb=0 sd=0 m=1
.ends
