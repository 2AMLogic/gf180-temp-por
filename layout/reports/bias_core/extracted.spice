* extracted by klt extract --deck gf180mcu

* cell bias_core
* pin BIAS_OK
* pin IBIAS
* pin VDD
* pin VREF
* pin VSS
* pin vsubs
.SUBCKT bias_core BIAS_OK IBIAS VDD VREF VSS vsubs
* device instance $1 r0 *1 159.4,0.5 nfet
M$1 VDD VDD \$17 vsubs nfet L=8U W=1U AS=0.8P AD=0.8P PS=3.6U PD=3.6U
* device instance $2 r0 *1 170,0.5 nfet
M$2 \$17 \$17 \$18 vsubs nfet L=8U W=1U AS=0.8P AD=0.8P PS=3.6U PD=3.6U
* device instance $3 r0 *1 180.6,0.5 nfet
M$3 \$18 \$18 \$19 vsubs nfet L=8U W=1U AS=0.8P AD=0.8P PS=3.6U PD=3.6U
* device instance $4 r0 *1 191.2,0.5 nfet
M$4 \$19 \$19 \$20 vsubs nfet L=8U W=1U AS=0.8P AD=0.8P PS=3.6U PD=3.6U
* device instance $5 r0 *1 201.8,0.5 nfet
M$5 \$20 \$20 \$21 vsubs nfet L=8U W=1U AS=0.8P AD=0.8P PS=3.6U PD=3.6U
* device instance $6 r0 *1 223.6,0.5 nfet
M$6 \$3 \$21 VSS vsubs nfet L=4U W=1U AS=0.8P AD=0.8P PS=3.6U PD=3.6U
* device instance $7 r0 *1 112.4,1 nfet
M$7 \$6 \$6 VSS vsubs nfet L=4U W=2U AS=1.6P AD=1.6P PS=5.6U PD=5.6U
* device instance $8 r0 *1 119,1 nfet
M$8 \$7 \$6 VSS vsubs nfet L=4U W=2U AS=1.6P AD=1.6P PS=5.6U PD=5.6U
* device instance $9 r0 *1 210.4,1 nfet
M$9 \$12 \$12 VSS vsubs nfet L=4U W=2U AS=1.6P AD=1.6P PS=5.6U PD=5.6U
* device instance $10 r0 *1 230.2,1 nfet
M$10 \$15 \$15 VSS vsubs nfet L=4U W=2U AS=1.6P AD=1.6P PS=5.6U PD=5.6U
* device instance $11 r0 *1 236.8,1 nfet
M$11 \$14 \$15 VSS vsubs nfet L=4U W=2U AS=1.6P AD=1.6P PS=5.6U PD=5.6U
* device instance $12 r0 *1 241.9,1 nfet
M$12 \$14 \$21 VSS vsubs nfet L=1U W=2U AS=1.6P AD=1.6P PS=5.6U PD=5.6U
* device instance $13 r0 *1 247,1 nfet
M$13 \$16 \$14 VSS vsubs nfet L=4U W=2U AS=1.6P AD=1.6P PS=5.6U PD=5.6U
* device instance $14 r0 *1 127.6,2 nfet
M$14 \$10 \$10 VSS vsubs nfet L=8U W=4U AS=3.2P AD=3.2P PS=9.6U PD=9.6U
* device instance $15 r0 *1 138.2,2 nfet
M$15 \$11 \$10 VSS vsubs nfet L=8U W=4U AS=3.2P AD=3.2P PS=9.6U PD=9.6U
* device instance $16 r0 *1 251.85,2 nfet
M$16 BIAS_OK \$16 VSS vsubs nfet L=0.5U W=4U AS=3.2P AD=3.2P PS=9.6U PD=9.6U
* device instance $17 r0 *1 148.8,4 nfet
M$17 \$3 \$11 VSS vsubs nfet L=8U W=8U AS=6.4P AD=6.4P PS=17.6U PD=17.6U
* device instance $18 r0 *1 217,4 nfet
M$18 \$21 \$12 VSS vsubs nfet L=4U W=8U AS=6.4P AD=6.4P PS=17.6U PD=17.6U
* device instance $19 r0 *1 68.8,0.5 pfet
M$19 \$12 \$7 VDD \$38 pfet L=4U W=1U AS=0.8P AD=0.8P PS=3.6U PD=3.6U
* device instance $20 r0 *1 75.4,0.5 pfet
M$20 \$13 \$7 VDD \$38 pfet L=4U W=1U AS=0.8P AD=0.8P PS=3.6U PD=3.6U
* device instance $21 r0 *1 95.2,0.5 pfet
M$21 \$16 \$7 VDD \$38 pfet L=4U W=1U AS=0.8P AD=0.8P PS=3.6U PD=3.6U
* device instance $22 r0 *1 101.8,0.5 pfet
M$22 BIAS_OK \$16 VDD \$38 pfet L=4U W=1U AS=0.8P AD=0.8P PS=3.6U PD=3.6U
* device instance $23 r0 *1 22.6,1 pfet
M$23 \$6 \$3 VDD \$38 pfet L=4U W=2U AS=1.6P AD=1.6P PS=5.6U PD=5.6U
* device instance $24 r0 *1 29.2,1 pfet
M$24 \$7 \$7 VDD \$38 pfet L=4U W=2U AS=1.6P AD=1.6P PS=5.6U PD=5.6U
* device instance $25 r0 *1 42.4,1 pfet
M$25 \$9 \$7 VDD \$38 pfet L=4U W=2U AS=1.6P AD=1.6P PS=5.6U PD=5.6U
* device instance $26 r0 *1 62.2,1 pfet
M$26 \$3 \$7 VDD \$38 pfet L=4U W=2U AS=1.6P AD=1.6P PS=5.6U PD=5.6U
* device instance $27 r0 *1 2.8,4 pfet
M$27 \$35 \$3 VDD \$38 pfet L=4U W=8U AS=6.4P AD=6.4P PS=17.6U PD=17.6U
* device instance $28 r0 *1 9.4,4 pfet
M$28 \$4 \$3 VDD \$38 pfet L=4U W=8U AS=6.4P AD=6.4P PS=17.6U PD=17.6U
* device instance $29 r0 *1 16,4 pfet
M$29 VREF \$3 VDD \$38 pfet L=4U W=8U AS=6.4P AD=6.4P PS=17.6U PD=17.6U
* device instance $30 r0 *1 82,4 pfet
M$30 \$14 \$35 \$13 \$38 pfet L=4U W=8U AS=6.4P AD=6.4P PS=17.6U PD=17.6U
* device instance $31 r0 *1 88.6,4 pfet
M$31 \$15 \$4 \$13 \$38 pfet L=4U W=8U AS=6.4P AD=6.4P PS=17.6U PD=17.6U
* device instance $32 r0 *1 49,8 pfet
M$32 \$10 \$35 \$9 \$38 pfet L=4U W=16U AS=12.8P AD=12.8P PS=33.6U PD=33.6U
* device instance $33 r0 *1 55.6,8 pfet
M$33 \$11 \$23 \$9 \$38 pfet L=4U W=16U AS=12.8P AD=12.8P PS=33.6U PD=33.6U
* device instance $34 r0 *1 35.8,20 pfet
M$34 IBIAS \$7 VDD \$38 pfet L=4U W=40U AS=32P AD=32P PS=81.6U PD=81.6U
* device instance $35 r0 *1 278.9,18 bjt
Q$35 vsubs \$26 \$24 bjt AE=100P PE=40U AB=169P PB=52U AC=169P PC=52U NE=1
* device instance $36 r0 *1 293.9,18 bjt
Q$36 vsubs \$26 \$24 bjt AE=100P PE=40U AB=169P PB=52U AC=169P PC=52U NE=1
* device instance $37 r0 *1 308.9,18 bjt
Q$37 vsubs \$26 \$24 bjt AE=100P PE=40U AB=169P PB=52U AC=169P PC=52U NE=1
* device instance $38 r0 *1 278.9,33 bjt
Q$38 vsubs \$26 \$24 bjt AE=100P PE=40U AB=169P PB=52U AC=169P PC=52U NE=1
* device instance $39 r0 *1 293.9,33 bjt
Q$39 vsubs \$26 \$35 bjt AE=100P PE=40U AB=169P PB=52U AC=169P PC=52U NE=1
* device instance $40 r0 *1 308.9,33 bjt
Q$40 vsubs \$26 \$24 bjt AE=100P PE=40U AB=169P PB=52U AC=169P PC=52U NE=1
* device instance $41 r0 *1 323.9,33 bjt
Q$41 vsubs \$26 \$36 bjt AE=100P PE=40U AB=169P PB=52U AC=169P PC=52U NE=1
* device instance $42 r0 *1 278.9,48 bjt
Q$42 vsubs \$26 \$24 bjt AE=100P PE=40U AB=169P PB=52U AC=169P PC=52U NE=1
* device instance $43 r0 *1 293.9,48 bjt
Q$43 vsubs \$26 \$24 bjt AE=100P PE=40U AB=169P PB=52U AC=169P PC=52U NE=1
* device instance $44 r0 *1 308.9,48 bjt
Q$44 vsubs \$26 \$24 bjt AE=100P PE=40U AB=169P PB=52U AC=169P PC=52U NE=1
* device instance $45 r0 *1 292.4,70.7 cap_mim_2f0_m4m5_noshield
C$45 \$40 \$42 7.2e-14 cap_mim_2f0_m4m5_noshield
* device instance $46 r0 *1 276.6,77.7 cap_mim_2f0_m4m5_noshield
C$46 \$39 \$41 8e-13 cap_mim_2f0_m4m5_noshield
* device instance $47 r0 *1 342.9,141.25 ppolyf_u_1k
R$47 VREF \$48 vsubs 128250 ppolyf_u_1k
* device instance $48 r0 *1 345.9,141.25 ppolyf_u_1k
R$48 \$34 \$48 vsubs 128250 ppolyf_u_1k
* device instance $49 r0 *1 348.9,141.25 ppolyf_u_1k
R$49 \$34 \$49 vsubs 128250 ppolyf_u_1k
* device instance $50 r0 *1 351.9,141.25 ppolyf_u_1k
R$50 \$33 \$49 vsubs 128250 ppolyf_u_1k
* device instance $51 r0 *1 354.9,141.25 ppolyf_u_1k
R$51 \$33 \$50 vsubs 128250 ppolyf_u_1k
* device instance $52 r0 *1 357.9,141.25 ppolyf_u_1k
R$52 \$32 \$50 vsubs 128250 ppolyf_u_1k
* device instance $53 r0 *1 360.9,141.25 ppolyf_u_1k
R$53 \$32 \$51 vsubs 128250 ppolyf_u_1k
* device instance $54 r0 *1 363.9,141.25 ppolyf_u_1k
R$54 \$31 \$51 vsubs 128250 ppolyf_u_1k
* device instance $55 r0 *1 366.9,141.25 ppolyf_u_1k
R$55 \$31 \$52 vsubs 128250 ppolyf_u_1k
* device instance $56 r0 *1 369.9,141.25 ppolyf_u_1k
R$56 \$30 \$52 vsubs 128250 ppolyf_u_1k
* device instance $57 r0 *1 372.9,141.25 ppolyf_u_1k
R$57 \$30 \$47 vsubs 128250 ppolyf_u_1k
* device instance $58 r0 *1 375.9,141.25 ppolyf_u_1k
R$58 \$29 \$47 vsubs 128250 ppolyf_u_1k
* device instance $59 r0 *1 378.9,141.25 ppolyf_u_1k
R$59 \$29 \$46 vsubs 128250 ppolyf_u_1k
* device instance $60 r0 *1 381.9,141.25 ppolyf_u_1k
R$60 \$28 \$46 vsubs 128250 ppolyf_u_1k
* device instance $61 r0 *1 384.9,141.25 ppolyf_u_1k
R$61 \$28 \$53 vsubs 128250 ppolyf_u_1k
* device instance $62 r0 *1 387.9,141.25 ppolyf_u_1k
R$62 \$36 \$53 vsubs 128250 ppolyf_u_1k
* device instance $63 r0 *1 394.9,140 ppolyf_u_1k
R$63 \$25 \$45 vsubs 127000 ppolyf_u_1k
* device instance $64 r0 *1 397.9,140 ppolyf_u_1k
R$64 \$27 \$45 vsubs 127000 ppolyf_u_1k
* device instance $65 r0 *1 400.9,140 ppolyf_u_1k
R$65 \$27 \$44 vsubs 127000 ppolyf_u_1k
* device instance $66 r0 *1 403.9,140 ppolyf_u_1k
R$66 \$11 \$44 vsubs 127000 ppolyf_u_1k
* device instance $67 r0 *1 410.9,100.5 ppolyf_u_1k
R$67 \$23 \$43 vsubs 87500 ppolyf_u_1k
* device instance $68 r0 *1 413.9,100.5 ppolyf_u_1k
R$68 \$24 \$43 vsubs 87500 ppolyf_u_1k
* device instance $69 r0 *1 420.9,17.375 ppolyf_u_1k
R$69 \$4 \$37 vsubs 4375 ppolyf_u_1k
* device instance $70 r0 *1 423.9,17.375 ppolyf_u_1k
R$70 \$23 \$37 vsubs 4375 ppolyf_u_1k
.ENDS bias_core
