* tb_por_deglitch_postlayout -- GENERATED by sim/build_tb.py
* Do not edit. Sources:
*   sim/por-output-chain-deglitch/testbench/stimulus.spice
*   layout/postlayout/por_output_chain.spice  (sha256 3d6e84ccb08651c7d07e9b343a937b64b2395f0860b677fdb88eb017a062f3a5)
* Regenerate with:
*   python3 sim/build_tb.py

* por-output-chain-deglitch -- stimulus half of the testbench fragment.
*
* The other half is a verbatim copy of design/netlist/por_output_chain.spice,
* appended by sim/build_tb.py to produce tb_por_deglitch.spice. Edit THIS file
* (or the schematic), never the generated fragment.
*
* Netlist FRAGMENT: no .include / .lib / .temp / .control / .end -- the
* harness owns those. Parameters it supplies: vdd_val, vdd_nom, temp_c.
*
* WHAT THIS EXPERIMENT SUBSTANTIATES
*
* spec/target-spec.md#por-brownout owns a TBD this issue has to fill: the
* deglitch dwell time, which must be <= T_dip,min for the brownout row to hold
* at all. Per DR-005 the dwell is this cell's job and is a separate,
* time-domain mechanism from the comparator's static hysteresis (#10) -- the
* two are not interchangeable and must not be double-counted.
*
* T_dip,min IS 30 us, NOT 10 us, SINCE DR-027 (#251)
*
* The 10 us this file was written against was an internal deglitch-dwell
* target, set when the cell was costed against an idealised 0.5x nominal bias.
* DR-024 measured the current the assembly really delivers to this cell
* (91.0251 nA, 0.182x nominal) and at that bias the filter does not reach its
* trip point inside 10 us at ANY of the 81 PVT points. DR-027 (ratified
* 2026-08-11, operator, #236) re-costs T_dip,min to the dwell the cell
* actually achieves there; #251 measured it with control/run_dwell_sweep.py:
*
*   slowest crossing, stress bias, 81 points x both netlist levels
*                                          23.110 us  (ss/-40C/3.63V, schematic)
*   T_dip,min(new), by the rule fixed in that script
*   (smallest multiple of 5 us >= 1.10x the slowest)      30 us  (+29.8 %)
*
* No point failed to trip at any dwell -- control/dwell_results.md shows all
* 324 (point, netlist, bias) probe runs crossing well inside a 600 us dip --
* so DR-027 section 5's contingency (a corner with an asymptotic floor above
* trip, which no re-cost could fix) is not triggered.
*
* Three things are measured, all on the same run:
*
*   1. DWELL. POR_RAW falls; how long until RESETn is asserted again? That is
*      the deglitch dwell plus a few ns of logic, and it is what T_dip,min has
*      to exceed. Measured end-to-end at the pin on xdut1, and also at the
*      internal PGDG node so the dwell can be attributed to the filter rather
*      than to the rest of the chain.
*   2. QUALIFYING-DIP CAPTURE. The dip used for (1) is exactly 30 us -- the
*      spec's own T_dip,min, post-DR-027 -- not a comfortable long one. A dwell
*      that is nominally under 30 us but creeps over it at a corner shows up
*      here as a RESETn that never reaches a valid low, which the vmin check
*      catches. On the stress DUT the dwell itself is also published as
*      dwell_pgdg_stress_us, so the record carries the measured per-corner
*      number the bound was cut from, not only the pass/fail against it.
*   3. NO EARLY / DOUBLE PULSE. Sub-dwell chatter on POR_RAW is applied twice:
*      once while RESETn is asserted (must not restart or truncate the pulse,
*      and must not produce an early release) and once after it has released
*      (must not produce a spurious re-assertion). This is the "POR_RAW
*      chatters near threshold before the deglitch settles" edge case.
*   4. REJECTION-WIDTH MARGIN (#200). A THIRD chatter burst, 1.05 us wide --
*      5 % wider than the 1 us the checks above use -- is applied after the
*      qualifying dip has restarted the pulse. Its job is to put a number on
*      how much width margin the filter has left, at every one of the 81 PVT
*      points, instead of only asserting that one width is rejected. What it
*      measures is the one-shot's own charge (TIM before vs. its minimum over
*      the burst), because losing timer charge -- XMDIS conducting and the
*      reset pulse restarting -- is the functional failure; PGDG merely
*      drooping is not.
*
*      WHY 1.05 us. control/width_results.md walks the glitch width at the two
*      fastest corners and brackets the post-layout netlist's rejection ceiling
*      between 1.0 us (rejected) and 1.25 us (disturbed) -- the schematic's
*      bracket is 1.75 / 2.0 us. 1.05 us is inside that bracket: wider than the
*      burst the checks above use, and still a width the design AS DRAWN
*      rejects at every one of the 81 points, which is what makes it a check
*      rather than a known failure. The control answers this at two corners
*      and is overwritten on every run; this burst carries the same question
*      onto the corner grid, where the answer is recorded append-only.
*
*      It sits AFTER every other measurement window on purpose: nothing in
*      this stimulus changes before 12.99 ms, so every measurement that
*      existed before it did is bit-identical to a run without it (verified
*      across all 81 points, both netlists) and the records stay comparable.
*      #251's re-cut of the qualifying dip from 10 us to 30 us moved this
*      burst 20 us later with it, so its offset from the pulse restart stays
*      exactly the 1.0/1.1/1.2 ms the paragraph above depends on; every
*      measurement window in tb.json still brackets it unchanged.
*
* TWO DUTS, BECAUSE THE DWELL SCALES AS 1/IBIAS
*
*   xdut1  IBIAS = 0.5 uA       DR-005 nominal. Carries the end-to-end RESETn
*                               measurements, which need a prior release and
*                               therefore a timer that finishes in time.
*   xdut2  IBIAS = 91.0251 nA   the stress case for the dwell bound, since
*                               less bias current means a slower filter. This
*                               is the arm T_dip,min itself is cut from (see
*                               the DR-027 block above), so its dwell is now
*                               published per corner as dwell_pgdg_stress_us
*                               as well as being checked as a voltage floor.
*                               Re-cut by issue #221 from an idealised 0.5x
*                               nominal (0.25 uA) to the worst-case CURRENT
*                               THE ASSEMBLY ACTUALLY DELIVERS to this cell's
*                               own IBIAS pin: 0.182x nominal, measured across
*                               the full 81-point PVT grid in BOTH RESETn
*                               states by sim/por-output-chain-ibias-sharing/
*                               (bias_core sharing the node with a possibly-
*                               enabled temp_core and por_comparator, per
*                               DR-010). The binding point is RESETn
*                               RELEASED, ss/-40C/2.97V, post-layout record
*                               sim/por-output-chain-ibias-sharing/records/
*                               20260811-142901-d43c0db.md (91.0251 nA; the
*                               schematic-level record beside it,
*                               20260811-142426-a9cdd7f.md, puts its own worst
*                               point at 91.0761 nA -- not materially
*                               different, and
*                               design/por_output_chain.md's own "XMBD/IBIAS
*                               watch item" already confirms the extraction
*                               adds no series impedance on this path). This
*                               is a single FIXED value applied uniformly
*                               across the whole PVT grid, exactly as the
*                               idealised 0.25 uA it replaces was -- the
*                               worst-case *delivered* current, not a
*                               per-corner-matched one; see
*                               design/por_output_chain.md's "Hand-off to
*                               #11" section for why this is the correct
*                               stress direction. Its timer takes far longer
*                               than xdut1's to finish, so only its internal
*                               PGDG dwell is asserted on; that is the filter
*                               output and is the number the spec row
*                               actually constrains. The measurement it is
*                               asserted on CHANGES NAME with this re-cut:
*                               dwell_pgdg_halfib_us (a WHEN-based crossing
*                               TIME) becomes pgdg_min_during_halfib_dip_v (a
*                               voltage floor sampled over the qualifying dip
*                               itself), because at this current the filter is
*                               frequently too slow to trip at all inside the
*                               dip and a crossing-time measure errors out of
*                               its search interval rather than reporting the
*                               FAIL. Records minted before this commit carry
*                               the old key; they are not edited, and both
*                               keys mean "the dwell against T_dip,min on the
*                               stress DUT". The "halfib" in the new key is
*                               likewise historical -- the leg is no longer
*                               literally half nominal. Since #251 the
*                               crossing-time measure is BACK alongside it, as
*                               dwell_pgdg_stress_us: at the re-cost T_dip,min
*                               of 30 us the crossing lands inside the dip at
*                               every one of the 81 points on both netlists
*                               (6.14-23.11 us, control/dwell_results.md), so
*                               it no longer errors out of its interval, and
*                               the record needs the dwell itself -- not only
*                               its pass/fail -- to show what margin the bound
*                               was cut with.
*
* TIMELINE
*
*   0     -> 100 us   VDD ramps 0 -> vdd_val. POR_RAW low.
*   300 us            POR_RAW high: release conditions met, both timers start.
*   1.0 / 1.1 / 1.2 ms  three 1 us LOW glitches on POR_RAW, DURING assertion.
*   (<=10 ms)         xdut1 releases -- once.
*   11.0 / 11.1 / 11.2 ms  three 1 us LOW glitches, AFTER release.
*   12.0 ms           POR_RAW low for exactly 30 us: the qualifying brownout
*                     dip of the por-brownout row, at DR-027's re-cost
*                     T_dip,min. RESETn must re-assert and the full pulse must
*                     regenerate.
*   13.02 / 13.12 / 13.22 ms  three 1.05 us LOW glitches, DURING the regenerated
*                     pulse -- placed at the same 1.0/1.1/1.2 ms offset from
*                     the restart at 12.03 ms that the first battery has from
*                     the start at 300.1 us, so the one-shot is charging
*                     steadily in both, the same regime. The regenerated pulse
*                     is >4 ms at every corner recorded so far, so RESETn is
*                     still asserted throughout this burst.
*   13.6 ms           end.

vsup vdd 0 PWL(0 0 100u {vdd_val} 14m {vdd_val})

* POR_RAW: high from 300 us, with three batteries of sub-dwell chatter (two at
* 1 us, one at 1.05 us) and one 30 us qualifying dip. Edges are 100 ns so the
* glitches are genuinely as wide at the pin as they are drawn here rather than
* being softened into nothing by the source.
vpr por_raw 0 PWL(0 0
+ 300u 0 300.1u {vdd_val}
+ 999.9u {vdd_val} 1000u 0 1001u 0 1001.1u {vdd_val}
+ 1099.9u {vdd_val} 1100u 0 1101u 0 1101.1u {vdd_val}
+ 1199.9u {vdd_val} 1200u 0 1201u 0 1201.1u {vdd_val}
+ 10999.9u {vdd_val} 11000u 0 11001u 0 11001.1u {vdd_val}
+ 11099.9u {vdd_val} 11100u 0 11101u 0 11101.1u {vdd_val}
+ 11199.9u {vdd_val} 11200u 0 11201u 0 11201.1u {vdd_val}
+ 11999.9u {vdd_val} 12000u 0 12030u 0 12030.1u {vdd_val}
+ 13019.9u {vdd_val} 13020u 0 13021.05u 0 13021.15u {vdd_val}
+ 13119.9u {vdd_val} 13120u 0 13121.05u 0 13121.15u {vdd_val}
+ 13219.9u {vdd_val} 13220u 0 13221.05u 0 13221.15u {vdd_val}
+ 14m {vdd_val})

Bib1 vdd nib1 i='500n*min(1, max(0, (v(vdd)-1.5)/0.5))'
vib1 nib1 ibias1 dc 0
Bib2 vdd nib2 i='91.0251n*min(1, max(0, (v(vdd)-1.5)/0.5))'
vib2 nib2 ibias2 dc 0

vd1 vdd vdd1 dc 0
vd2 vdd vdd2 dc 0

Cl1 resetn1 0 5p
Rl1 resetn1 0 1T
Cl2 resetn2 0 5p
Rl2 resetn2 0 1T

xdut1 vdd1 0 ibias1 por_raw resetn1 por_output_chain
xdut2 vdd2 0 ibias2 por_raw resetn2 por_output_chain

* por_output_chain -- post-layout netlist
* GENERATED by layout/postlayout.py -- do not edit.
*
* FROM THE LAYOUT: every device and its dimensions, the whole
*   topology, and first-order interconnect R/C on 18/18 nets
*   (sigma 901.4 fF, of which 81.195 fF is net-to-net coupling).
*   One star per net: <net> is the hub, <net>__t<k> each device
*   terminal on it, R<net>_t<k> the arm between them.
*   klt 0.6.0, deck gf180mcu,
*   GDS sha256 79a1439bdf87109c...
* Net names are the schematic's, restored through klt lvs's own net
*   correspondence -- match, 18/18 nets, every one paired.
*
* NOT FROM THE LAYOUT -- see layout/postlayout/AUDIT.md:
*   2 body/plate net(s) tied to the net the schematic puts
*   them on. The extraction deck's connectivity stack does not reach
*   an Nwell, a substrate ring, a bipolar base well or a MiM plate,
*   so they extract isolated and would otherwise float.
*   No ideal device: every golden device is drawn.
*
.subckt por_output_chain VDD VSS IBIAS POR_RAW RESETn

* --- drawn devices ---
X1 PDN__t0 IBIAS__t0 VSS__t0 VSS__t17 nfet_03v3 L=25u W=0.5u nf=1 ad=0.4p as=0.4p pd=2.6u ps=2.6u m=1
X2 PGDGB__t2 PGDG__t3 VSS__t1 VSS__t18 nfet_03v3 L=2u W=0.5u nf=1 ad=0.4p as=0.4p pd=2.6u ps=2.6u m=1
X3 ND1__t1 NDL__t0 VSS__t2 VSS__t19 nfet_03v3 L=10u W=0.5u nf=1 ad=0.4p as=0.4p pd=2.6u ps=2.6u m=1
X4 NDG__t2 POR_RAW__t1 NDGN__t0 VSS__t20 nfet_03v3 L=0.5u W=1u nf=1 ad=0.8p as=0.8p pd=3.6u ps=3.6u m=1
X5 TIM__t4 PGDGB__t3 VSS__t3 VSS__t21 nfet_03v3 L=1u W=1u nf=1 ad=0.8p as=0.8p pd=3.6u ps=3.6u m=1
X6 TRIP__t3 ND1__t3 VSS__t16 VSS__t22 nfet_03v3 L=1u W=1u nf=1 ad=0.8p as=0.8p pd=3.6u ps=3.6u m=1
X7 ND1__t2 RESETn__t2 VSS__t15 VSS__t23 nfet_03v3 L=1u W=1u nf=1 ad=0.8p as=0.8p pd=3.6u ps=3.6u m=1
X8 NDL__t1 NDL__t2 VSS__t4 VSS__t24 nfet_03v3 L=10u W=2u nf=1 ad=1.6p as=1.6p pd=5.6u ps=5.6u m=1
X9 PGDG__t4 NDG__t3 VSS__t5 VSS__t25 nfet_03v3 L=0.5u W=2u nf=1 ad=1.6p as=1.6p pd=5.6u ps=5.6u m=1
X10 RSTB__t4 TRIP__t1 NNAND__t1 VSS__t26 nfet_03v3 L=0.5u W=2u nf=1 ad=1.6p as=1.6p pd=5.6u ps=5.6u m=1
X11 NNAND__t0 PGDG__t5 VSS__t14 VSS__t27 nfet_03v3 L=0.5u W=2u nf=1 ad=1.6p as=1.6p pd=5.6u ps=5.6u m=1
X12 IBIAS__t1 IBIAS__t2 VSS__t6 VSS__t28 nfet_03v3 L=4u W=4u nf=1 ad=3.2p as=3.2p pd=9.6u ps=9.6u m=1
X13 NDGN__t1 NDL__t3 VSS__t7 VSS__t29 nfet_03v3 L=10u W=10u nf=1 ad=8p as=8p pd=21.6u ps=21.6u m=1
X14 RESETn__t0 RSTB__t0 VSS__t8 VSS__t30 nfet_03v3 L=0.5u W=10u nf=1 ad=8p as=8p pd=21.6u ps=21.6u m=1
X15 NTS__t0 PDN__t1 VDD__t0 VDD__t1 pfet_03v3 L=10u W=0.5u nf=1 ad=0.4p as=0.4p pd=2.6u ps=2.6u m=1
X16 TRIP__t2 PDN__t6 VDD__t25 VDD__t23 pfet_03v3 L=10u W=0.5u nf=1 ad=0.4p as=0.4p pd=2.6u ps=2.6u m=1
X17 PGDG__t0 NDG__t0 VDD__t2 VDD__t3 pfet_03v3 L=2u W=0.5u nf=1 ad=0.4p as=0.4p pd=2.6u ps=2.6u m=1
X18 RSTB__t5 RESETn__t3 VDD__t24 VDD__t22 pfet_03v3 L=10u W=0.5u nf=1 ad=0.4p as=0.4p pd=2.6u ps=2.6u m=1
X19 NDG__t1 POR_RAW__t0 NDGP__t0 VDD__t4 pfet_03v3 L=0.5u W=1u nf=1 ad=0.8p as=0.8p pd=3.6u ps=3.6u m=1
X20 RESETn__t1 RSTB__t1 VDD__t5 VDD__t6 pfet_03v3 L=1u W=1u nf=1 ad=0.8p as=0.8p pd=3.6u ps=3.6u m=1
X21 PDN__t2 PDN__t3 VDD__t7 VDD__t8 pfet_03v3 L=10u W=2u nf=1 ad=1.6p as=1.6p pd=5.6u ps=5.6u m=1
X22 NDL__t4 PDN__t5 VDD__t21 VDD__t20 pfet_03v3 L=10u W=2u nf=1 ad=1.6p as=1.6p pd=5.6u ps=5.6u m=1
X23 PGDGB__t0 PGDG__t1 VDD__t9 VDD__t10 pfet_03v3 L=0.5u W=2u nf=1 ad=1.6p as=1.6p pd=5.6u ps=5.6u m=1
X24 TIM__t5 PGDGB__t1 NTS__t1 VDD__t11 pfet_03v3 L=1u W=2u nf=1 ad=1.6p as=1.6p pd=5.6u ps=5.6u m=1
X25 ND1__t0 TIM__t6 VDD__t12 VDD__t19 pfet_03v3 L=1u W=2u nf=1 ad=1.6p as=1.6p pd=5.6u ps=5.6u m=1
X26 RSTB__t2 TRIP__t0 VDD__t13 VDD__t14 pfet_03v3 L=0.5u W=4u nf=1 ad=3.2p as=3.2p pd=9.6u ps=9.6u m=1
X27 RSTB__t3 PGDG__t2 VDD__t18 VDD__t17 pfet_03v3 L=0.5u W=4u nf=1 ad=3.2p as=3.2p pd=9.6u ps=9.6u m=1
X28 NDGP__t1 PDN__t4 VDD__t15 VDD__t16 pfet_03v3 L=10u W=10u nf=1 ad=8p as=8p pd=21.6u ps=21.6u m=1
X29 NDG__t4 VSS__t9 cap_mim_2f0_m3m4_noshield c_width=11u c_length=11u
X30 TIM__t0 VSS__t10 cap_mim_2f0_m3m4_noshield c_width=28u c_length=28u
X31 TIM__t3 VSS__t13 cap_mim_2f0_m3m4_noshield c_width=28u c_length=28u
X32 TIM__t2 VSS__t12 cap_mim_2f0_m3m4_noshield c_width=28u c_length=28u
X33 TIM__t1 VSS__t11 cap_mim_2f0_m3m4_noshield c_width=28u c_length=28u

R_10_t0 NDGN__t0 NDGN 1968.54035
R_10_t1 NDGN__t1 NDGN 1968.54035
C_10 NDGN VSS 3.4262384e-14
R_11_t0 NDG__t0 NDG 1014.07506597
R_11_t1 NDG__t1 NDG 954.603905263
R_11_t2 NDG__t2 NDG 719.797860447
R_11_t3 NDG__t3 NDG 671.322091399
R_11_t4 NDG__t4 NDG 740.648776922
C_11 NDG VSS 5.2682676e-14
R_12_t0 PGDG__t0 PGDG 602.446318769
R_12_t1 PGDG__t1 PGDG 654.828626133
R_12_t2 PGDG__t2 PGDG 837.510194981
R_12_t3 PGDG__t3 PGDG 818.584937735
R_12_t4 PGDG__t4 PGDG 870.985079265
R_12_t5 PGDG__t5 PGDG 405.068343117
C_12 PGDG VSS 4.2322747e-14
R_13_t0 TIM__t0 TIM 550.192925008
R_13_t1 TIM__t1 TIM 450.44845788
R_13_t2 TIM__t2 TIM 646.825671411
R_13_t3 TIM__t3 TIM 295.351686536
R_13_t4 TIM__t4 TIM 305.553184754
R_13_t5 TIM__t5 TIM 892.679198138
R_13_t6 TIM__t6 TIM 921.604176272
C_13 TIM VSS 8.4756315e-14
R_14_t0 TRIP__t0 TRIP 1336.10142733
R_14_t1 TRIP__t1 TRIP 928.634222318
R_14_t2 TRIP__t2 TRIP 694.201632009
R_14_t3 TRIP__t3 TRIP 1101.25331834
C_14 TRIP VSS 3.9432796e-14
R_15_t0 NNAND__t0 NNAND 1969.9799
R_15_t1 NNAND__t1 NNAND 1969.9799
C_15 NNAND VSS 3.5401418e-14
R_16_t0 NDGP__t0 NDGP 1968.36045
R_16_t1 NDGP__t1 NDGP 1968.36045
C_16 NDGP VSS 3.4117005e-14
R_17_t0 RSTB__t0 RSTB 754.19830579
R_17_t1 RSTB__t1 RSTB 577.101205748
R_17_t2 RSTB__t2 RSTB 125.223191397
R_17_t3 RSTB__t3 RSTB 198.604997756
R_17_t4 RSTB__t4 RSTB 2034.86326663
R_17_t5 RSTB__t5 RSTB 386.186232677
C_17 RSTB VSS 4.4183369e-14
R_2_t0 PDN__t0 PDN 2192.18513758
R_2_t1 PDN__t1 PDN 753.814003433
R_2_t2 PDN__t2 PDN 119.940253161
R_2_t3 PDN__t3 PDN 119.940253161
R_2_t4 PDN__t4 PDN 470.418947224
R_2_t5 PDN__t5 PDN 171.383237922
R_2_t6 PDN__t6 PDN 1044.80236751
C_2 PDN VSS 5.6528747e-14
R_3_t0 NDL__t0 NDL 418.160636306
R_3_t1 NDL__t1 NDL 878.61286536
R_3_t2 NDL__t2 NDL 878.61286536
R_3_t3 NDL__t3 NDL 479.294941313
R_3_t4 NDL__t4 NDL 1807.81299166
C_3 NDL VSS 4.7374149e-14
R_5_t0 PGDGB__t0 PGDGB 985.115471459
R_5_t1 PGDGB__t1 PGDGB 1048.31915217
R_5_t2 PGDGB__t2 PGDGB 1055.41000903
R_5_t3 PGDGB__t3 PGDGB 978.029067333
C_5 PGDGB VSS 3.8921287e-14
R_6_t0 ND1__t0 ND1 2004.66951985
R_6_t1 ND1__t1 ND1 851.440640246
R_6_t2 ND1__t2 ND1 526.661303231
R_6_t3 ND1__t3 ND1 626.580236676
C_6 ND1 VSS 3.9492693e-14
R_8_t0 NTS__t0 NTS 1969.2657
R_8_t1 NTS__t1 NTS 1969.2657
C_8 NTS VSS 3.4836444e-14
RIBIAS_t0 IBIAS__t0 IBIAS 2199.33055
RIBIAS_t1 IBIAS__t1 IBIAS 1099.665275
RIBIAS_t2 IBIAS__t2 IBIAS 1099.665275
CIBIAS IBIAS VSS 4.5280553e-14
RPOR_RAW_t0 POR_RAW__t0 POR_RAW 2023.6421
RPOR_RAW_t1 POR_RAW__t1 POR_RAW 2023.6421
CPOR_RAW POR_RAW VSS 3.435215e-14
RRESETn_t0 RESETn__t0 RESETn 883.591221836
RRESETn_t1 RESETn__t1 RESETn 700.167162863
RRESETn_t2 RESETn__t2 RESETn 2080.85833879
RRESETn_t3 RESETn__t3 RESETn 502.463076507
CRESETn RESETn VSS 4.4258787e-14
RVDD_t0 VDD__t0 VDD 2.35999148776
RVDD_t1 VDD__t1 VDD 2.35999148776
RVDD_t2 VDD__t2 VDD 0.788098333131
RVDD_t3 VDD__t3 VDD 0.788098333131
RVDD_t4 VDD__t4 VDD 0.295249720716
RVDD_t5 VDD__t5 VDD 5.06439905244
RVDD_t6 VDD__t6 VDD 5.06439905244
RVDD_t7 VDD__t7 VDD 7.23527963295
RVDD_t8 VDD__t8 VDD 7.23527963295
RVDD_t9 VDD__t9 VDD 1.2760983336
RVDD_t10 VDD__t10 VDD 1.2760983336
RVDD_t11 VDD__t11 VDD 1.70838162397
RVDD_t12 VDD__t12 VDD 2.17294680535
RVDD_t13 VDD__t13 VDD 2.60734965526
RVDD_t14 VDD__t14 VDD 2.60734965526
RVDD_t15 VDD__t15 VDD 4.01357304527
RVDD_t16 VDD__t16 VDD 4.01357304527
RVDD_t17 VDD__t17 VDD 3.00712811554
RVDD_t18 VDD__t18 VDD 3.00712811554
RVDD_t19 VDD__t19 VDD 2.17294680535
RVDD_t20 VDD__t20 VDD 5.60920221824
RVDD_t21 VDD__t21 VDD 5.60920221824
RVDD_t22 VDD__t22 VDD 4.02007759857
RVDD_t23 VDD__t23 VDD 0.740540049554
RVDD_t24 VDD__t24 VDD 4.02007759857
RVDD_t25 VDD__t25 VDD 0.740540049554
CVDD VDD VSS 6.8863152e-14
RVSS_t0 VSS__t0 VSS 3.0504807567
RVSS_t1 VSS__t1 VSS 0.623413386554
RVSS_t2 VSS__t2 VSS 0.926502729824
RVSS_t3 VSS__t3 VSS 0.633889397759
RVSS_t4 VSS__t4 VSS 1.8412251982
RVSS_t5 VSS__t5 VSS 0.647622869458
RVSS_t6 VSS__t6 VSS 4.07178625969
RVSS_t7 VSS__t7 VSS 1.02751523267
RVSS_t8 VSS__t8 VSS 8.86000647857
RVSS_t9 VSS__t9 VSS 1.68526577635
RVSS_t10 VSS__t10 VSS 3.92540218501
RVSS_t11 VSS__t11 VSS 4.32044174866
RVSS_t12 VSS__t12 VSS 5.23235681228
RVSS_t13 VSS__t13 VSS 2.58794153849
RVSS_t14 VSS__t14 VSS 1.89460679736
RVSS_t15 VSS__t15 VSS 1.53287091387
RVSS_t16 VSS__t16 VSS 1.33211712448
RVSS_t17 VSS__t17 VSS 3.0504807567
RVSS_t18 VSS__t18 VSS 0.623413386554
RVSS_t19 VSS__t19 VSS 0.926502729824
RVSS_t20 VSS__t20 VSS 0.778793901586
RVSS_t21 VSS__t21 VSS 0.633889397759
RVSS_t22 VSS__t22 VSS 1.33211712448
RVSS_t23 VSS__t23 VSS 1.53287091387
RVSS_t24 VSS__t24 VSS 1.8412251982
RVSS_t25 VSS__t25 VSS 0.647622869458
RVSS_t26 VSS__t26 VSS 1.71372374734
RVSS_t27 VSS__t27 VSS 1.89460679736
RVSS_t28 VSS__t28 VSS 4.07178625969
RVSS_t29 VSS__t29 VSS 1.02751523267
RVSS_t30 VSS__t30 VSS 8.86000647857
CVSS VSS VSS 1.24338142e-13
Ccc__11__12 NDG PGDG 4.7222e-17
Ccc__11__13 NDG TIM 5.0173e-17
Ccc__11__14 NDG TRIP 4.7222e-17
Ccc__11__15 NDG NNAND 2.3611e-17
Ccc__11__17 NDG RSTB 7.0832e-17
Ccc__11__5 NDG PGDGB 4.7222e-17
Ccc__11__6 NDG ND1 4.7222e-17
Ccc__11__8 NDG NTS 2.3611e-17
Ccc__11_RESETn NDG RESETn 4.7222e-17
Ccc__11_VDD NDG VDD 1.5347e-16
Ccc__11_VSS NDG VSS 3.269281e-15
Ccc__13__14 TIM TRIP 4.7222e-17
Ccc__13__15 TIM NNAND 2.3611e-17
Ccc__13__17 TIM RSTB 7.0832e-17
Ccc__13__6 TIM ND1 4.7222e-17
Ccc__13_RESETn TIM RESETn 4.7222e-17
Ccc__13_VDD TIM VDD 1.5347e-16
Ccc__13_VSS TIM VSS 7.697882e-14
Rvsubs_dctie VSS 0 1e+12
.ends por_output_chain
