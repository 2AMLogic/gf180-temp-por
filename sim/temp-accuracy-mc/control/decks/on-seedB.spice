* temp-accuracy-mc mismatch-switch control @ tt / 27.0 C / 3.3 V -- GENERATED by run_mismatch_switch.py, do not edit
* sw_stat_mismatch override: .param sw_stat_mismatch=1   placement: after the .include   seed: 2002
* pdk=gf180mcuD@c6d73a35f524070e85faff4a6a9eef49553ebc2b

.option seed=2002

.include "/Users/rwalters/.volare/gf180mcuD/libs.tech/ngspice/design.ngspice"
.lib "/Users/rwalters/.volare/gf180mcuD/libs.tech/ngspice/sm141064.ngspice" typical
.lib "/Users/rwalters/.volare/gf180mcuD/libs.tech/ngspice/sm141064.ngspice" res_typical
.lib "/Users/rwalters/.volare/gf180mcuD/libs.tech/ngspice/sm141064.ngspice" bjt_typical
.lib "/Users/rwalters/.volare/gf180mcuD/libs.tech/ngspice/sm141064.ngspice" diode_typical
.lib "/Users/rwalters/.volare/gf180mcuD/libs.tech/ngspice/sm141064.ngspice" moscap_typical
.lib "/Users/rwalters/.volare/gf180mcuD/libs.tech/ngspice/sm141064.ngspice" mimcap_typical

.param sw_stat_mismatch=1

.temp 27.0
.options reltol=1e-5
.options abstol=1e-15
.options vntol=1e-9

.include "../mismatch_switch.spice"
.include "../../../../design/netlist/temp_core.spice"

.control
set numdgt=10
set noaskquit
op
print v(ptat)
print v(ctat)
print v(xdut.na)
print v(xdut.nb)
print v(xdut.nc)
.endc
.end
