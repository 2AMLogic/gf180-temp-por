* por-brownout -- stimulus half of the testbench fragment.
*
* The other half is a verbatim copy of design/netlist/temp_por_top.spice,
* appended by sim/build_tb.py to produce tb_por_brownout.spice. Edit THIS
* file (or the schematics), never the generated fragment.
*
* Netlist FRAGMENT: no .include / .lib / .temp / .control / .end -- the
* harness owns those. Parameters it supplies: vdd_val, vdd_nom, temp_c.
*
* WHAT THIS EXPERIMENT SUBSTANTIATES
*
* spec/target-spec.md#por-brownout: a dip that (a) takes VDD below
* VPOR-downarrow,min = 2.22 V and (b) stays below VPOR-downarrow for
* >= T_dip,min = 10 us must re-assert RESETn and regenerate the FULL
* [por-reset-pulse] (>=1 ms), on the full four-cell assembly with bias_core's
* real (starved, corner-dependent) recovery dynamics in the loop -- not the
* idealised-bias por_output_chain-only deglitch check
* sim/por-output-chain-deglitch/ already ran.
*
* It also carries the full-assembly confirmation of
* spec/target-spec.md#por-reset-pulse that #14 owes: the >=1 ms minimum was
* measured at the single-cell level by #12 (sim/por-output-chain-pulse/, min
* 4.21535 ms at ff/-40C/2.97V), and t_pulse_regen_ms below is the same
* quantity measured end to end on the assembled block, in the brownout
* context, at every corner -- including the observed MAXIMUM, which the
* ratified row explicitly asks #14 to record ("#14 records the observed max
* so a maximum can be added later on evidence").
*
* WHY A DEEP DIP: design/bias_core.md's "starved-loop window" documents that
* a FULL rail collapse leaves BIAS_OK reading a false valid for
* 326-1567 us while the reference loop crawls back (measured on bias_core
* alone, idealised load). This deck's dip goes to 1.0 V -- below every
* corner's comparator/reference operating floor (sim/por-comparator-
* designer-check/'s below-floor probes) -- so it exercises the SAME
* recovery path a full collapse does, but from a bounded starting point
* rather than 0 V, matching "brownout" rather than "power-cycle". If the
* starved-loop window shows up here as a longer-than-#12's-idealised-record
* reassert or release delay, that is the ALREADY-OWNED, ALREADY-TRACKED
* finding design/bias_core.md assigns to #1/#14 -- record it, do not
* root-cause it fresh (see design/bias_core.md, "The starved-loop window").
*
* TIMESTEP: the manifest asks for `tran 20u 55m`, i.e. a 20 us ceiling on the
* step in QUIET regions only. Both dip edges are PWL breakpoints ngspice
* lands on exactly, and the rail slews 2.0-2.6 V in 1 us across each of
* them, so local truncation error drives the step orders of magnitude below
* the ceiling through the whole disturbance -- which is where
* `t_reassert_us` (bounded at 50 us) is resolved. The ceiling only governs
* the two long static holds, where the full four-cell assembly would
* otherwise spend most of its ~12 ms-per-step solve cost resolving nothing.
*
* PAD LOAD: 1 pF plus a 1 Tohm DC leak on each of PTAT and CTAT, matching
* sim/temp-por-top-release/ and sim/temp-accuracy-vt/ exactly. The resistors
* are not a model of anything physical -- they are the DC reference the two
* analogue pads need in the state this deck spends most of its time in.
* While RESETn is asserted temp_core is disabled and its outputs are high
* impedance (DR-010's disabled-consumer contract), so without them PTAT and
* CTAT are capacitively coupled floating nodes, and ngspice's local
* truncation error control collapses the timestep trying to track them: an
* early revision of these decks, identical but for these four lines, ran
* >450 s of CPU per PVT point without completing, against ~36 s for the
* comparable 30 ms transient in sim/temp-por-top-release/. 1 Tohm at a
* ~1.3 V pad is 1.3 pA, four to five orders of magnitude below the block's
* own nanoamp-scale currents, so it references the node without loading it.
*
* ONE DUT, ONE TRAN, staged as a timeline (the multi-stage idiom
* sim/bias-core-startup/'s `xbo` branch already uses):
*
*   0    ->  1 ms   cold start: VDD ramps 0 -> vdd_val in 1 ms (2970-3630
*                    V/s, inside the ratified por-ramp-rate envelope and the
*                    exact cold start sim/temp-por-top-release/ validates
*                    releases correctly at all 81 points).
*    1   -> 20 ms   held at vdd_val -- rail settled, RESETn released.
*                    sim/temp-por-top-release/ measures release complete by
*                    16.95 ms at the slowest corner (ss/-40C/3.63V) off this
*                    same 1 ms ramp, so 20 ms leaves 3 ms of margin.
*   20   -> 20.001 ms   VDD dips from vdd_val to 1.0 V over 1 us.
*   20.001 -> 20.051 ms  held at 1.0 V for 50 us -- 5x T_dip,min = 10 us, and
*                    well above the 1.86-8.88 us deglitch dwell
*                    sim/por-output-chain-deglitch/ measured at the cell
*                    level (idealised bias), so this is unambiguously a
*                    QUALIFYING dip, not a glitch (that is sim/por-glitch/'s
*                    job).
*   20.051 -> 20.052 ms  VDD recovers from 1.0 V to vdd_val over 1 us.
*   20.052 -> 55 ms  held at vdd_val -- RESETn must have re-asserted during
*                    the dip and must now regenerate a full
*                    [por-reset-pulse] (>=1 ms) before releasing again. The
*                    35 ms of recovery observation is sized off the
*                    end-to-end release time sim/temp-por-top-release/
*                    measures on this same assembly (5.6-17.0 ms) plus the
*                    starved-loop window design/bias_core.md measures after
*                    a collapse (up to 1.57 ms) -- i.e. roughly 2x the
*                    slowest expected recovery, so a corner that takes
*                    longer than expected still lands inside the run and is
*                    measured rather than silently reported as "no data".

vsup vdd 0 PWL(
+ 0        0
+ 1m       {vdd_val}
+ 20m      {vdd_val}
+ 20.001m  1.0
+ 20.051m  1.0
+ 20.052m  {vdd_val}
+ 55m      {vdd_val}
+ )

Cpp ptat 0 1p
Cpc ctat 0 1p
Rlp ptat 0 1T
Rlc ctat 0 1T
Crn resetn 0 5p

xdut vdd 0 ptat ctat resetn temp_por_top
