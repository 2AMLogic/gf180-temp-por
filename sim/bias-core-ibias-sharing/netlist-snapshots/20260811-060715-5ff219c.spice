* Frozen netlist snapshot for record 20260811-060715-5ff219c
* source     : sim/bias-core-ibias-sharing/testbench-postlayout/tb_ibias_sharing.spice
* sha256     : 8fee22a554719d0d7138779af5fe4b33e19562a63c818d0c5b24d6d37ce996ef
* This is a verbatim copy taken at record time. Do not edit.
* tb_ibias_sharing -- GENERATED by sim/build_tb.py
* Do not edit. Sources:
*   sim/bias-core-ibias-sharing/testbench/stimulus.spice
*   layout/postlayout/bias_core.spice  (sha256 2a04a0b6f0f58318c2bcda10c2d03b421fa9b76452f97d22ed234ac0bcdc44bd)
*   layout/postlayout/temp_core.spice  (sha256 87f220c5391ecb4f0dbbe7d628119ec0dfd9ea0ca3115c70a6ce7436da73e6ae)
*   layout/postlayout/por_comparator.spice  (sha256 b6875e1abe48b7722efe59150dd9fefc0f2a0fb7c569851aedb1181217d1e404)
* Regenerate with:
*   python3 sim/build_tb.py --postlayout bias-core-ibias-sharing

* bias-core-ibias-sharing -- stimulus half of the testbench fragment.
*
* The other half is a verbatim copy of design/netlist/bias_core.spice,
* design/netlist/temp_core.spice and design/netlist/por_comparator.spice,
* appended by sim/build_tb.py to produce tb_ibias_sharing.spice. Edit THIS
* file (or the schematics), never the generated fragment.
*
* Netlist FRAGMENT: no .include / .lib / .temp / .control / .end -- the
* harness owns those. Parameters it supplies: vdd_val, vdd_nom, temp_c.
*
* WHY THIS EXPERIMENT EXISTS
*
* Issue #11 is chartered to "prove no bias-vs-POR chicken-and-egg lockup
* state exists across corners". bias_core on its own cannot answer that,
* because the lockup candidate does not live inside any one cell: IBIAS is a
* SINGLE shared net at the top level
*
*   xbias VDD VSS IBIAS VREF BIAS_OK       bias_core
*   xtemp VDD VSS IBIAS RESETn PTAT CTAT   temp_core
*   xcmp  VDD VSS IBIAS VREF BIAS_OK POR_RAW  por_comparator
*   xpor  VDD VSS IBIAS POR_RAW RESETn     por_output_chain
*
* (design/netlist/temp_por_top.spice), and DR-005 startup ordering step 6
* holds temp_core DISABLED until POR releases. temp_core's disabled state
* clamps the IBIAS *pin* to VSS through its XMDIB device -- deliberately, and
* documented in design/temp_core.md ("Disabled state"), which also says that
* if the resulting pre-POR draw matters "the fix belongs in bias_core (gate
* its own output), not here".
*
* Two branches, identical except for whether the disabled temp_core is
* present on the shared net:
*
*   A. the real top-level wiring in the reset-asserted state: bias_core +
*      a DISABLED temp_core + por_comparator, EN = 0 (RESETn asserted).
*   B. the control: the same rail, the same bias_core and por_comparator,
*      with temp_core absent -- i.e. what design/por-comparator-designer-
*      check assumed when it drove IBIAS from an ideal 500 nA source.
*
* Both are held at this point's vdd_val, which is above every corner's
* release threshold, so branch B must release (POR_RAW high). Whether branch
* A does too is the whole question.
*
* por_output_chain is NOT instantiated: it is still #12's placeholder (its
* IBIAS pin terminates in a 1 Tohm resistor), so it can neither load nor
* clamp the shared net and adding it would only slow the deck down.
*
* The rail is ramped rather than DC-stepped so both branches start from a
* real cold start; the measurements are taken well after settling.

* ---- A. top-level wiring, reset asserted ----------------------------
vsupa vdda 0 PWL(0 0 100u {vdd_val} 1 {vdd_val})
vena  ena  0 dc 0
viba  niba ibiasa dc 0
xbiasa vdda 0 niba vrefa oka bias_core
xtempa vdda 0 ibiasa ena ptata ctata temp_core
xcmpa  vdda 0 ibiasa vrefa oka por_rawa por_comparator
Rpta ptata 0 1T
Rcta ctata 0 1T

* ---- B. control: no temp_core on the shared net ---------------------
vsupb vddb 0 PWL(0 0 100u {vdd_val} 1 {vdd_val})
vibb  nibb ibiasb dc 0
xbiasb vddb 0 nibb vrefb okb bias_core
xcmpb  vddb 0 ibiasb vrefb okb por_rawb por_comparator

* bias_core -- post-layout netlist
* GENERATED by layout/postlayout.py -- do not edit.
*
* FROM THE LAYOUT: every device and its dimensions, the whole
*   topology, and first-order interconnect R/C on 47/54 nets
*   (sigma 1920.0 fF). klt 0.2.0, deck gf180mcu,
*   GDS sha256 6d6236d05ae0cd82...
* Net names are the schematic's, restored through klt lvs's own net
*   correspondence -- match, 54/54 nets, every one paired.
*
* NOT FROM THE LAYOUT -- see layout/postlayout/AUDIT.md:
*   7 body/plate net(s) tied to the net the schematic puts
*   them on. The extraction deck's connectivity stack does not reach
*   an Nwell, a substrate ring, a bipolar base well or a MiM plate,
*   so they extract isolated and would otherwise float.
*   No ideal device: every golden device is drawn.
*
.subckt bias_core VDD VSS IBIAS VREF BIAS_OK

* --- drawn devices ---
X1 VDD VDD KS1 VSS nfet_03v3 L=8u W=1u nf=1 ad=0.8p as=0.8p pd=3.6u ps=3.6u m=1
X2 KS1 KS1 KS2 VSS nfet_03v3 L=8u W=1u nf=1 ad=0.8p as=0.8p pd=3.6u ps=3.6u m=1
X3 KS2 KS2 KS3 VSS nfet_03v3 L=8u W=1u nf=1 ad=0.8p as=0.8p pd=3.6u ps=3.6u m=1
X4 KS3 KS3 KS4 VSS nfet_03v3 L=8u W=1u nf=1 ad=0.8p as=0.8p pd=3.6u ps=3.6u m=1
X5 KS4 KS4 NKG VSS nfet_03v3 L=8u W=1u nf=1 ad=0.8p as=0.8p pd=3.6u ps=3.6u m=1
X6 PG NKG VSS VSS nfet_03v3 L=4u W=1u nf=1 ad=0.8p as=0.8p pd=3.6u ps=3.6u m=1
X7 NBG NBG VSS VSS nfet_03v3 L=4u W=2u nf=1 ad=1.6p as=1.6p pd=5.6u ps=5.6u m=1
X8 PB NBG VSS VSS nfet_03v3 L=4u W=2u nf=1 ad=1.6p as=1.6p pd=5.6u ps=5.6u m=1
X9 NKM NKM VSS VSS nfet_03v3 L=4u W=2u nf=1 ad=1.6p as=1.6p pd=5.6u ps=5.6u m=1
X10 NOKL NOKL VSS VSS nfet_03v3 L=4u W=2u nf=1 ad=1.6p as=1.6p pd=5.6u ps=5.6u m=1
X11 NOKO NOKL VSS VSS nfet_03v3 L=4u W=2u nf=1 ad=1.6p as=1.6p pd=5.6u ps=5.6u m=1
X12 NOKO NKG VSS VSS nfet_03v3 L=1u W=2u nf=1 ad=1.6p as=1.6p pd=5.6u ps=5.6u m=1
X13 NOKX NOKO VSS VSS nfet_03v3 L=4u W=2u nf=1 ad=1.6p as=1.6p pd=5.6u ps=5.6u m=1
X14 N1 N1 VSS VSS nfet_03v3 L=8u W=4u nf=1 ad=3.2p as=3.2p pd=9.6u ps=9.6u m=1
X15 N2 N1 VSS VSS nfet_03v3 L=8u W=4u nf=1 ad=3.2p as=3.2p pd=9.6u ps=9.6u m=1
X16 BIAS_OK NOKX VSS VSS nfet_03v3 L=0.5u W=4u nf=1 ad=3.2p as=3.2p pd=9.6u ps=9.6u m=1
X17 PG N2 VSS VSS nfet_03v3 L=8u W=8u nf=1 ad=6.4p as=6.4p pd=17.6u ps=17.6u m=1
X18 NKG NKM VSS VSS nfet_03v3 L=4u W=8u nf=1 ad=6.4p as=6.4p pd=17.6u ps=17.6u m=1
X19 NKM PB VDD VDD pfet_03v3 L=4u W=1u nf=1 ad=0.8p as=0.8p pd=3.6u ps=3.6u m=1
X20 TOK PB VDD VDD pfet_03v3 L=4u W=1u nf=1 ad=0.8p as=0.8p pd=3.6u ps=3.6u m=1
X21 NOKX PB VDD VDD pfet_03v3 L=4u W=1u nf=1 ad=0.8p as=0.8p pd=3.6u ps=3.6u m=1
X22 BIAS_OK NOKX VDD VDD pfet_03v3 L=4u W=1u nf=1 ad=0.8p as=0.8p pd=3.6u ps=3.6u m=1
X23 NBG PG VDD VDD pfet_03v3 L=4u W=2u nf=1 ad=1.6p as=1.6p pd=5.6u ps=5.6u m=1
X24 PB PB VDD VDD pfet_03v3 L=4u W=2u nf=1 ad=1.6p as=1.6p pd=5.6u ps=5.6u m=1
X25 NT PB VDD VDD pfet_03v3 L=4u W=2u nf=1 ad=1.6p as=1.6p pd=5.6u ps=5.6u m=1
X26 PG PB VDD VDD pfet_03v3 L=4u W=2u nf=1 ad=1.6p as=1.6p pd=5.6u ps=5.6u m=1
X27 NA PG VDD VDD pfet_03v3 L=4u W=8u nf=1 ad=6.4p as=6.4p pd=17.6u ps=17.6u m=1
X28 NBTOP PG VDD VDD pfet_03v3 L=4u W=8u nf=1 ad=6.4p as=6.4p pd=17.6u ps=17.6u m=1
X29 VREF PG VDD VDD pfet_03v3 L=4u W=8u nf=1 ad=6.4p as=6.4p pd=17.6u ps=17.6u m=1
X30 NOKO NA TOK VDD pfet_03v3 L=4u W=8u nf=1 ad=6.4p as=6.4p pd=17.6u ps=17.6u m=1
X31 NOKL NBTOP TOK VDD pfet_03v3 L=4u W=8u nf=1 ad=6.4p as=6.4p pd=17.6u ps=17.6u m=1
X32 N1 NA NT VDD pfet_03v3 L=4u W=16u nf=1 ad=12.8p as=12.8p pd=33.6u ps=33.6u m=1
X33 N2 NB NT VDD pfet_03v3 L=4u W=16u nf=1 ad=12.8p as=12.8p pd=33.6u ps=33.6u m=1
X34 IBIAS PB VDD VDD pfet_03v3 L=4u W=40u nf=1 ad=32p as=32p pd=81.6u ps=81.6u m=1
X35 VSS VSS EC pnp_10p00x10p00
X36 VSS VSS EC pnp_10p00x10p00
X37 VSS VSS EC pnp_10p00x10p00
X38 VSS VSS EC pnp_10p00x10p00
X39 VSS VSS NA pnp_10p00x10p00
X40 VSS VSS EC pnp_10p00x10p00
X41 VSS VSS ER pnp_10p00x10p00
X42 VSS VSS EC pnp_10p00x10p00
X43 VSS VSS EC pnp_10p00x10p00
X44 VSS VSS EC pnp_10p00x10p00
X45 NOKX VDD cap_mim_2f0_m3m4_noshield c_width=6u c_length=6u
X46 NZ PG cap_mim_2f0_m3m4_noshield c_width=20u c_length=20u
X47 VREF XR2__1 VSS ppolyf_u_3k r_width=2u r_length=256.5u
X48 XR2__2 XR2__1 VSS ppolyf_u_3k r_width=2u r_length=256.5u
X49 XR2__2 XR2__3 VSS ppolyf_u_3k r_width=2u r_length=256.5u
X50 XR2__4 XR2__3 VSS ppolyf_u_3k r_width=2u r_length=256.5u
X51 XR2__4 XR2__5 VSS ppolyf_u_3k r_width=2u r_length=256.5u
X52 XR2__6 XR2__5 VSS ppolyf_u_3k r_width=2u r_length=256.5u
X53 XR2__6 XR2__7 VSS ppolyf_u_3k r_width=2u r_length=256.5u
X54 XR2__8 XR2__7 VSS ppolyf_u_3k r_width=2u r_length=256.5u
X55 XR2__8 XR2__9 VSS ppolyf_u_3k r_width=2u r_length=256.5u
X56 XR2__10 XR2__9 VSS ppolyf_u_3k r_width=2u r_length=256.5u
X57 XR2__10 XR2__11 VSS ppolyf_u_3k r_width=2u r_length=256.5u
X58 XR2__12 XR2__11 VSS ppolyf_u_3k r_width=2u r_length=256.5u
X59 XR2__12 XR2__13 VSS ppolyf_u_3k r_width=2u r_length=256.5u
X60 XR2__14 XR2__13 VSS ppolyf_u_3k r_width=2u r_length=256.5u
X61 XR2__14 XR2__15 VSS ppolyf_u_3k r_width=2u r_length=256.5u
X62 ER XR2__15 VSS ppolyf_u_3k r_width=2u r_length=256.5u
X63 NZ XRZ__1 VSS ppolyf_u_3k r_width=2u r_length=254u
X64 XRZ__2 XRZ__1 VSS ppolyf_u_3k r_width=2u r_length=254u
X65 XRZ__2 XRZ__3 VSS ppolyf_u_3k r_width=2u r_length=254u
X66 N2 XRZ__3 VSS ppolyf_u_3k r_width=2u r_length=254u
X67 NB XR1__1 VSS ppolyf_u_3k r_width=2u r_length=175u
X68 EC XR1__1 VSS ppolyf_u_3k r_width=2u r_length=175u
X69 NBTOP XRT__1 VSS ppolyf_u_3k r_width=2u r_length=8.75u
X70 NB XRT__1 VSS ppolyf_u_3k r_width=2u r_length=8.75u

R_10 N1 N1__par 4967.8583
C_10 N1__par VSS 5.978126e-14
R_11 N2 N2__par 7855.0506
C_11 N2__par VSS 8.4779094e-14
R_12 NKM NKM__par 4876.8874
C_12 NKM__par VSS 5.7923066e-14
R_13 TOK TOK__par 4690.5254
C_13 TOK__par VSS 5.2350545e-14
R_14 NOKO NOKO__par 4792.4183
C_14 NOKO__par VSS 5.9161863e-14
R_15 NOKL NOKL__par 4883.997
C_15 NOKL__par VSS 6.0794305e-14
R_16 NOKX NOKX__par 4848.4085
C_16 NOKX__par VSS 5.9751918e-14
R_17 KS1 KS1__par 4818.8511
C_17 KS1__par VSS 5.4330567e-14
R_18 KS2 KS2__par 4819.3911
C_18 KS2__par VSS 5.4548635e-14
R_19 KS3 KS3__par 4819.931
C_19 KS3__par VSS 5.4766704e-14
R_20 KS4 KS4__par 4820.471
C_20 KS4__par VSS 5.4984773e-14
R_21 NKG NKG__par 4848.0503
C_21 NKG__par VSS 5.7785044e-14
R_23 NB NB__par 7667.0394
C_23 NB__par VSS 7.6118691e-14
R_24 EC EC__par 2791.7858
C_24 EC__par VSS 7.4268842e-14
R_25 NZ NZ__par 2787.2554
C_25 NZ__par VSS 2.545538e-14
R_27 XRZ__2 XRZ__2__par 18.25
C_27 XRZ__2__par VSS 1.8067e-15
R_28 XR2__14 XR2__14__par 18.25
C_28 XR2__14__par VSS 1.8067e-15
R_29 XR2__12 XR2__12__par 18.25
C_29 XR2__12__par VSS 1.8067e-15
R_3 PG PG__par 5084.0134
C_3 PG__par VSS 6.8147207e-14
R_30 XR2__10 XR2__10__par 18.25
C_30 XR2__10__par VSS 1.8067e-15
R_31 XR2__8 XR2__8__par 18.25
C_31 XR2__8__par VSS 1.8067e-15
R_32 XR2__6 XR2__6__par 18.25
C_32 XR2__6__par VSS 1.8067e-15
R_33 XR2__4 XR2__4__par 18.25
C_33 XR2__4__par VSS 1.8067e-15
R_34 XR2__2 XR2__2__par 18.25
C_34 XR2__2__par VSS 1.8067e-15
R_35 NA NA__par 8008.5898
C_35 NA__par VSS 8.7590412e-14
R_36 ER ER__par 2787.674
C_36 ER__par VSS 3.3170077e-14
R_37 XRT__1 XRT__1__par 18.25
C_37 XRT__1__par VSS 1.8067e-15
R_4 NBTOP NBTOP__par 7796.7657
C_4 NBTOP__par VSS 7.8325844e-14
R_43 XR1__1 XR1__1__par 18.25
C_43 XR1__1__par VSS 1.8067e-15
R_44 XRZ__3 XRZ__3__par 18.25
C_44 XRZ__3__par VSS 1.8067e-15
R_45 XRZ__1 XRZ__1__par 18.25
C_45 XRZ__1__par VSS 1.8067e-15
R_46 XR2__13 XR2__13__par 18.25
C_46 XR2__13__par VSS 1.8067e-15
R_47 XR2__11 XR2__11__par 18.25
C_47 XR2__11__par VSS 1.8067e-15
R_48 XR2__1 XR2__1__par 18.25
C_48 XR2__1__par VSS 1.8067e-15
R_49 XR2__3 XR2__3__par 18.25
C_49 XR2__3__par VSS 1.8067e-15
R_50 XR2__5 XR2__5__par 18.25
C_50 XR2__5__par VSS 1.8067e-15
R_51 XR2__7 XR2__7__par 18.25
C_51 XR2__7__par VSS 1.8067e-15
R_52 XR2__9 XR2__9__par 18.25
C_52 XR2__9__par VSS 1.8067e-15
R_53 XR2__15 XR2__15__par 18.25
C_53 XR2__15__par VSS 1.8067e-15
R_6 NBG NBG__par 4871.7578
C_6 NBG__par VSS 5.5851412e-14
R_7 PB PB__par 5396.0003
C_7 PB__par VSS 7.9168117e-14
R_9 NT NT__par 4684.5858
C_9 NT__par VSS 4.9951788e-14
RBIAS_OK BIAS_OK BIAS_OK__par 4679.0384
CBIAS_OK BIAS_OK__par VSS 4.7753184e-14
RIBIAS IBIAS IBIAS__par 4663.4113
CIBIAS IBIAS__par VSS 4.1483963e-14
RVDD VDD VDD__par 371.4414
CVDD VDD__par VSS 1.29011679e-13
RVREF VREF VREF__par 7695.5815
CVREF VREF__par VSS 7.3513489e-14
RVSS VSS VSS__par 145.0301
CVSS VSS__par VSS 2.53093198e-13
.ends bias_core

* temp_core -- post-layout netlist
* GENERATED by layout/postlayout.py -- do not edit.
*
* FROM THE LAYOUT: every device and its dimensions, the whole
*   topology, and first-order interconnect R/C on 69/73 nets
*   (sigma 1552.3 fF). klt 0.2.0, deck gf180mcu,
*   GDS sha256 852d534c2004326c...
* Net names are the schematic's, restored through klt lvs's own net
*   correspondence -- match, 73/73 nets, every one paired.
*
* NOT FROM THE LAYOUT -- see layout/postlayout/AUDIT.md:
*   4 body/plate net(s) tied to the net the schematic puts
*   them on. The extraction deck's connectivity stack does not reach
*   an Nwell, a substrate ring, a bipolar base well or a MiM plate,
*   so they extract isolated and would otherwise float.
*   XCC (cap_mim_2f0_m3m4_noshield) is IDEAL -- not drawn in this cell's layout -- reserved floor area.
*
.subckt temp_core VDD VSS IBIAS EN PTAT CTAT

* --- schematic-ideal, not drawn ---
XIDEAL1 PG NZ cap_mim_2f0_m3m4_noshield c_width=12u c_length=12u

* --- drawn devices ---
X1 VSS VSS VSS VSS nfet_03v3 L=8u W=4u nf=1 ad=3.2p as=3.2p pd=9.6u ps=9.6u m=1
X2 N1 N1 VSS VSS nfet_03v3 L=8u W=4u nf=1 ad=3.2p as=3.2p pd=9.6u ps=9.6u m=1
X3 N2 N1 VSS VSS nfet_03v3 L=8u W=4u nf=1 ad=3.2p as=3.2p pd=9.6u ps=9.6u m=1
X4 N2 N1 VSS VSS nfet_03v3 L=8u W=4u nf=1 ad=3.2p as=3.2p pd=9.6u ps=9.6u m=1
X5 N1 N1 VSS VSS nfet_03v3 L=8u W=4u nf=1 ad=3.2p as=3.2p pd=9.6u ps=9.6u m=1
X6 VSS VSS VSS VSS nfet_03v3 L=8u W=4u nf=1 ad=3.2p as=3.2p pd=9.6u ps=9.6u m=1
X7 PG N2 VSS VSS nfet_03v3 L=8u W=8u nf=1 ad=6.4p as=6.4p pd=17.6u ps=17.6u m=1
X8 IBIAS NBG VSS VSS nfet_03v3 L=2u W=4u nf=1 ad=3.2p as=3.2p pd=9.6u ps=9.6u m=1
X9 IBIAS EN NBG VSS nfet_03v3 L=0.5u W=2u nf=1 ad=1.6p as=1.6p pd=5.6u ps=5.6u m=1
X10 NBG ENB VSS VSS nfet_03v3 L=0.5u W=2u nf=1 ad=1.6p as=1.6p pd=5.6u ps=5.6u m=1
X11 PB NBG VSS VSS nfet_03v3 L=2u W=4u nf=1 ad=3.2p as=3.2p pd=9.6u ps=9.6u m=1
X12 PCAS NBG VSS VSS nfet_03v3 L=2u W=4u nf=1 ad=3.2p as=3.2p pd=9.6u ps=9.6u m=1
X13 ENB EN VSS VSS nfet_03v3 L=0.5u W=1u nf=1 ad=0.8p as=0.8p pd=3.6u ps=3.6u m=1
X14 ND NR VSS VSS nfet_03v3 L=2u W=2u nf=1 ad=1.6p as=1.6p pd=5.6u ps=5.6u m=1
X15 PG ND VSS VSS nfet_03v3 L=1u W=4u nf=1 ad=3.2p as=3.2p pd=9.6u ps=9.6u m=1
X16 NR NR VSS VSS nfet_03v3 L=2u W=2u nf=1 ad=1.6p as=1.6p pd=5.6u ps=5.6u m=1
X17 ND ENB VSS VSS nfet_03v3 L=0.5u W=2u nf=1 ad=1.6p as=1.6p pd=5.6u ps=5.6u m=1
X18 PTAT ENB VSS VSS nfet_03v3 L=1u W=1u nf=1 ad=0.8p as=0.8p pd=3.6u ps=3.6u m=1
X19 CTAT ENB VSS VSS nfet_03v3 L=1u W=1u nf=1 ad=0.8p as=0.8p pd=3.6u ps=3.6u m=1
X20 N2 ENB VSS VSS nfet_03v3 L=1u W=2u nf=1 ad=1.6p as=1.6p pd=5.6u ps=5.6u m=1
X21 NT ENB VSS VSS nfet_03v3 L=1u W=2u nf=1 ad=1.6p as=1.6p pd=5.6u ps=5.6u m=1
X22 T5 VDD T4 VSS nfet_03v3 L=0.5u W=32u nf=1 ad=25.6p as=25.6p pd=65.6u ps=65.6u m=1
X23 T3 VSS T2 VSS nfet_03v3 L=0.5u W=32u nf=1 ad=25.6p as=25.6p pd=65.6u ps=65.6u m=1
X24 T1 VSS T0 VSS nfet_03v3 L=0.5u W=32u nf=1 ad=25.6p as=25.6p pd=65.6u ps=65.6u m=1
X25 T0 VSS VSS VSS nfet_03v3 L=0.5u W=32u nf=1 ad=25.6p as=25.6p pd=65.6u ps=65.6u m=1
X26 T2 VSS T1 VSS nfet_03v3 L=0.5u W=32u nf=1 ad=25.6p as=25.6p pd=65.6u ps=65.6u m=1
X27 T4 VSS T3 VSS nfet_03v3 L=0.5u W=32u nf=1 ad=25.6p as=25.6p pd=65.6u ps=65.6u m=1
X28 NT NT NT NT pfet_03v3 L=4u W=16u nf=1 ad=12.8p as=12.8p pd=33.6u ps=33.6u m=1
X29 N1 NA NT NT pfet_03v3 L=4u W=16u nf=1 ad=12.8p as=12.8p pd=33.6u ps=33.6u m=1
X30 N2 NB NT NT pfet_03v3 L=4u W=16u nf=1 ad=12.8p as=12.8p pd=33.6u ps=33.6u m=1
X31 N2 NB NT NT pfet_03v3 L=4u W=16u nf=1 ad=12.8p as=12.8p pd=33.6u ps=33.6u m=1
X32 N1 NA NT NT pfet_03v3 L=4u W=16u nf=1 ad=12.8p as=12.8p pd=33.6u ps=33.6u m=1
X33 NT NT NT NT pfet_03v3 L=4u W=16u nf=1 ad=12.8p as=12.8p pd=33.6u ps=33.6u m=1
X34 NT PB VDD VDD pfet_03v3 L=4u W=20u nf=1 ad=16p as=16p pd=41.6u ps=41.6u m=1
X35 VDD VDD VDD VDD pfet_03v3 L=4u W=4u nf=1 ad=3.2p as=3.2p pd=9.6u ps=9.6u m=1
X36 M1D PG VDD VDD pfet_03v3 L=4u W=4u nf=1 ad=3.2p as=3.2p pd=9.6u ps=9.6u m=1
X37 NA PCAS M1D VDD pfet_03v3 L=1u W=4u nf=1 ad=3.2p as=3.2p pd=9.6u ps=9.6u m=1
X38 M2D PG VDD VDD pfet_03v3 L=4u W=4u nf=1 ad=3.2p as=3.2p pd=9.6u ps=9.6u m=1
X39 NB PCAS M2D VDD pfet_03v3 L=1u W=4u nf=1 ad=3.2p as=3.2p pd=9.6u ps=9.6u m=1
X40 M3D PG VDD VDD pfet_03v3 L=4u W=4u nf=1 ad=3.2p as=3.2p pd=9.6u ps=9.6u m=1
X41 PTAT PCAS M3D VDD pfet_03v3 L=1u W=4u nf=1 ad=3.2p as=3.2p pd=9.6u ps=9.6u m=1
X42 PTAT PCAS M3D VDD pfet_03v3 L=1u W=4u nf=1 ad=3.2p as=3.2p pd=9.6u ps=9.6u m=1
X43 M3D PG VDD VDD pfet_03v3 L=4u W=4u nf=1 ad=3.2p as=3.2p pd=9.6u ps=9.6u m=1
X44 NB PCAS M2D VDD pfet_03v3 L=1u W=4u nf=1 ad=3.2p as=3.2p pd=9.6u ps=9.6u m=1
X45 M2D PG VDD VDD pfet_03v3 L=4u W=4u nf=1 ad=3.2p as=3.2p pd=9.6u ps=9.6u m=1
X46 NA PCAS M1D VDD pfet_03v3 L=1u W=4u nf=1 ad=3.2p as=3.2p pd=9.6u ps=9.6u m=1
X47 M1D PG VDD VDD pfet_03v3 L=4u W=4u nf=1 ad=3.2p as=3.2p pd=9.6u ps=9.6u m=1
X48 VDD VDD VDD VDD pfet_03v3 L=4u W=4u nf=1 ad=3.2p as=3.2p pd=9.6u ps=9.6u m=1
X49 PG PB VDD VDD pfet_03v3 L=4u W=10u nf=1 ad=8p as=8p pd=21.6u ps=21.6u m=1
X50 PB PB VDD VDD pfet_03v3 L=4u W=10u nf=1 ad=8p as=8p pd=21.6u ps=21.6u m=1
X51 PCAS PCAS VDD VDD pfet_03v3 L=8u W=1u nf=1 ad=0.8p as=0.8p pd=3.6u ps=3.6u m=1
X52 ENB EN VDD VDD pfet_03v3 L=0.5u W=2u nf=1 ad=1.6p as=1.6p pd=5.6u ps=5.6u m=1
X53 ND PB VDD VDD pfet_03v3 L=8u W=1u nf=1 ad=0.8p as=0.8p pd=3.6u ps=3.6u m=1
X54 NR PG VDD VDD pfet_03v3 L=4u W=1u nf=1 ad=0.8p as=0.8p pd=3.6u ps=3.6u m=1
X55 PG EN VDD VDD pfet_03v3 L=0.5u W=4u nf=1 ad=3.2p as=3.2p pd=9.6u ps=9.6u m=1
X56 VSS VSS NC pnp_10p00x10p00
X57 VSS VSS NC pnp_10p00x10p00
X58 VSS VSS NC pnp_10p00x10p00
X59 VSS VSS NC pnp_10p00x10p00
X60 VSS VSS NA pnp_10p00x10p00
X61 VSS VSS NC pnp_10p00x10p00
X62 VSS VSS NC pnp_10p00x10p00
X63 VSS VSS NC pnp_10p00x10p00
X64 VSS VSS NC pnp_10p00x10p00
X65 NB XR1__1 VSS ppolyf_u r_width=2u r_length=59.735u
X66 NC XR1__1 VSS ppolyf_u r_width=2u r_length=59.735u
X67 NA XRISO__1 VSS ppolyf_u r_width=2u r_length=55.525u
X68 CTAT XRISO__1 VSS ppolyf_u r_width=2u r_length=55.525u
X69 NZ XRZ__1 VSS ppolyf_u r_width=2u r_length=100u
X70 XRZ__2 XRZ__1 VSS ppolyf_u r_width=2u r_length=100u
X71 XRZ__2 XRZ__3 VSS ppolyf_u r_width=2u r_length=100u
X72 XRZ__4 XRZ__3 VSS ppolyf_u r_width=2u r_length=100u
X73 XRZ__4 XRZ__5 VSS ppolyf_u r_width=2u r_length=100u
X74 XRZ__6 XRZ__5 VSS ppolyf_u r_width=2u r_length=100u
X75 XRZ__6 XRZ__7 VSS ppolyf_u r_width=2u r_length=100u
X76 XRZ__8 XRZ__7 VSS ppolyf_u r_width=2u r_length=100u
X77 XRZ__8 XRZ__9 VSS ppolyf_u r_width=2u r_length=100u
X78 N2 XRZ__9 VSS ppolyf_u r_width=2u r_length=100u
X79 PTAT XR2F__1 VSS ppolyf_u r_width=2u r_length=110.525u
X80 XR2F__2 XR2F__1 VSS ppolyf_u r_width=2u r_length=110.525u
X81 XR2F__2 XR2F__3 VSS ppolyf_u r_width=2u r_length=110.525u
X82 XR2F__4 XR2F__3 VSS ppolyf_u r_width=2u r_length=110.525u
X83 XR2F__4 XR2F__5 VSS ppolyf_u r_width=2u r_length=110.525u
X84 XR2F__6 XR2F__5 VSS ppolyf_u r_width=2u r_length=110.525u
X85 XR2F__6 XR2F__7 VSS ppolyf_u r_width=2u r_length=110.525u
X86 XR2F__8 XR2F__7 VSS ppolyf_u r_width=2u r_length=110.525u
X87 XR2F__8 XR2F__9 VSS ppolyf_u r_width=2u r_length=110.525u
X88 XR2F__10 XR2F__9 VSS ppolyf_u r_width=2u r_length=110.525u
X89 XR2F__10 XR2F__11 VSS ppolyf_u r_width=2u r_length=110.525u
X90 XR2F__12 XR2F__11 VSS ppolyf_u r_width=2u r_length=110.525u
X91 XR2F__12 XR2F__13 VSS ppolyf_u r_width=2u r_length=110.525u
X92 XR2F__14 XR2F__13 VSS ppolyf_u r_width=2u r_length=110.525u
X93 XR2F__14 XR2F__15 VSS ppolyf_u r_width=2u r_length=110.525u
X94 XR2F__16 XR2F__15 VSS ppolyf_u r_width=2u r_length=110.525u
X95 XR2F__16 XR2F__17 VSS ppolyf_u r_width=2u r_length=110.525u
X96 XR2F__18 XR2F__17 VSS ppolyf_u r_width=2u r_length=110.525u
X97 XR2F__18 XR2F__19 VSS ppolyf_u r_width=2u r_length=110.525u
X98 XR2F__20 XR2F__19 VSS ppolyf_u r_width=2u r_length=110.525u
X99 XR2F__20 XR2F__21 VSS ppolyf_u r_width=2u r_length=110.525u
X100 XR2F__22 XR2F__21 VSS ppolyf_u r_width=2u r_length=110.525u
X101 XR2F__22 XR2F__23 VSS ppolyf_u r_width=2u r_length=110.525u
X102 T5 XR2F__23 VSS ppolyf_u r_width=2u r_length=110.525u
X103 T5 XR2T5__1 VSS ppolyf_u r_width=2u r_length=114.855u
X104 T4 XR2T5__1 VSS ppolyf_u r_width=2u r_length=114.855u
X105 T4 XR2T4__1 VSS ppolyf_u r_width=2u r_length=57.345u
X106 T3 XR2T4__1 VSS ppolyf_u r_width=2u r_length=57.345u
X107 T3 XR2T3__1 VSS ppolyf_u r_width=2u r_length=28.59u
X108 T2 XR2T3__1 VSS ppolyf_u r_width=2u r_length=28.59u
X109 T2 XR2T2__1 VSS ppolyf_u r_width=2u r_length=14.21u
X110 T1 XR2T2__1 VSS ppolyf_u r_width=2u r_length=14.21u
X111 T1 XR2T1__1 VSS ppolyf_u r_width=2u r_length=7.015u
X112 T0 XR2T1__1 VSS ppolyf_u r_width=2u r_length=7.015u
X113 T0 XR2T0__1 VSS ppolyf_u r_width=2u r_length=3.425u
X114 VSS XR2T0__1 VSS ppolyf_u r_width=2u r_length=3.425u

R_30 XRZ__2 XRZ__2__par 50.5749
C_30 XRZ__2__par VSS 1.599507e-15
R_31 XRZ__4 XRZ__4__par 50.5749
C_31 XRZ__4__par VSS 1.599507e-15
R_32 XRZ__6 XRZ__6__par 50.5749
C_32 XRZ__6__par VSS 1.599507e-15
R_33 XRZ__8 XRZ__8__par 50.5749
C_33 XRZ__8__par VSS 1.599507e-15
R_34 XR2F__2 XR2F__2__par 50.5749
C_34 XR2F__2__par VSS 1.599507e-15
R_35 XR2F__4 XR2F__4__par 50.5749
C_35 XR2F__4__par VSS 1.599507e-15
R_36 XR2F__6 XR2F__6__par 50.5749
C_36 XR2F__6__par VSS 1.599507e-15
R_37 XR2F__8 XR2F__8__par 50.5749
C_37 XR2F__8__par VSS 1.599507e-15
R_38 XR2F__10 XR2F__10__par 50.5749
C_38 XR2F__10__par VSS 1.599507e-15
R_39 XR2F__12 XR2F__12__par 50.5749
C_39 XR2F__12__par VSS 1.599507e-15
R_40 XR2F__14 XR2F__14__par 50.5749
C_40 XR2F__14__par VSS 1.599507e-15
R_41 XR2F__16 XR2F__16__par 50.5749
C_41 XR2F__16__par VSS 1.599507e-15
R_42 XR2F__18 XR2F__18__par 50.5749
C_42 XR2F__18__par VSS 1.599507e-15
R_43 XR2F__20 XR2F__20__par 50.5749
C_43 XR2F__20__par VSS 1.599507e-15
R_44 XR2F__22 XR2F__22__par 50.5749
C_44 XR2F__22__par VSS 1.599507e-15
R_50 XR2T0__1 XR2T0__1__par 50.5749
C_50 XR2T0__1__par VSS 1.599507e-15
R_51 XR2T1__1 XR2T1__1__par 50.5749
C_51 XR2T1__1__par VSS 1.599507e-15
R_56 XR2T2__1 XR2T2__1__par 50.5749
C_56 XR2T2__1__par VSS 1.599507e-15
R_60 XR2T3__1 XR2T3__1__par 50.5749
C_60 XR2T3__1__par VSS 1.599507e-15
R_68 XRISO__1 XRISO__1__par 50.5749
C_68 XRISO__1__par VSS 1.599507e-15
R_69 XR2T4__1 XR2T4__1__par 50.5749
C_69 XR2T4__1__par VSS 1.599507e-15
R_70 XR1__1 XR1__1__par 50.5749
C_70 XR1__1__par VSS 1.599507e-15
R_71 XRZ__1 XRZ__1__par 50.5749
C_71 XRZ__1__par VSS 1.599507e-15
R_72 XRZ__3 XRZ__3__par 50.5749
C_72 XRZ__3__par VSS 1.599507e-15
R_73 XRZ__5 XRZ__5__par 50.5749
C_73 XRZ__5__par VSS 1.599507e-15
R_74 XRZ__7 XRZ__7__par 50.5749
C_74 XRZ__7__par VSS 1.599507e-15
R_75 XRZ__9 XRZ__9__par 50.5749
C_75 XRZ__9__par VSS 1.599507e-15
R_76 XR2F__1 XR2F__1__par 50.5749
C_76 XR2F__1__par VSS 1.599507e-15
R_77 XR2F__3 XR2F__3__par 50.5749
C_77 XR2F__3__par VSS 1.599507e-15
R_78 XR2F__5 XR2F__5__par 50.5749
C_78 XR2F__5__par VSS 1.599507e-15
R_79 XR2F__7 XR2F__7__par 50.5749
C_79 XR2F__7__par VSS 1.599507e-15
R_80 XR2F__9 XR2F__9__par 50.5749
C_80 XR2F__9__par VSS 1.599507e-15
R_81 XR2F__11 XR2F__11__par 50.5749
C_81 XR2F__11__par VSS 1.599507e-15
R_82 XR2F__13 XR2F__13__par 50.5749
C_82 XR2F__13__par VSS 1.599507e-15
R_83 XR2F__15 XR2F__15__par 50.5749
C_83 XR2F__15__par VSS 1.599507e-15
R_84 XR2F__17 XR2F__17__par 50.5749
C_84 XR2F__17__par VSS 1.599507e-15
R_85 XR2F__19 XR2F__19__par 50.5749
C_85 XR2F__19__par VSS 1.599507e-15
R_86 XR2F__21 XR2F__21__par 50.5749
C_86 XR2F__21__par VSS 1.599507e-15
R_87 XR2F__23 XR2F__23__par 50.5749
C_87 XR2F__23__par VSS 1.599507e-15
R_88 XR2T5__1 XR2T5__1__par 50.5749
C_88 XR2T5__1__par VSS 1.599507e-15
RCTAT CTAT CTAT__par 508.901
CCTAT CTAT__par VSS 3.2409351e-14
REN EN EN__par 1473.1873
CEN EN__par VSS 3.3733752e-14
RENB ENB ENB__par 1722.3174
CENB ENB__par VSS 3.6434644e-14
RIBIAS IBIAS IBIAS__par 322.6504
CIBIAS IBIAS__par VSS 2.0287657e-14
RM1D M1D M1D__par 1326.5002
CM1D M1D__par VSS 2.6584926e-14
RM2D M2D M2D__par 1250.9542
CM2D M2D__par VSS 2.5194004e-14
RM3D M3D M3D__par 1175.4138
CM3D M3D__par VSS 2.3803081e-14
RN1 N1 N1__par 3916.0744
CN1 N1__par VSS 3.9166451e-14
RN2 N2 N2__par 2349.712
CN2 N2__par VSS 5.2203575e-14
RNA NA NA__par 2133.218
CNA NA__par VSS 6.3089263e-14
RNB NB NB__par 2057.3709
CNB NB__par VSS 4.3487422e-14
RNBG NBG NBG__par 1144.9314
CNBG NBG__par VSS 2.6946068e-14
RNC NC NC__par 65.9407
CNC NC__par VSS 8.5417204e-14
RND ND ND__par 1512.6715
CND ND__par VSS 3.4769335e-14
RNR NR NR__par 1694.9168
CNR NR__par VSS 3.5399052e-14
RNT NT NT__par 5451.5605
CNT NT__par VSS 7.8898189e-14
RNZ NZ NZ__par 105.4542
CNZ NZ__par VSS 2.9318592e-14
RPB PB PB__par 3535.6753
CPB PB__par VSS 4.7145745e-14
RPCAS PCAS PCAS__par 4548.8647
CPCAS PCAS__par VSS 5.3738496e-14
RPG PG PG__par 5100.5412
CPG PG__par VSS 6.1711967e-14
RPTAT PTAT PTAT__par 962.4337
CPTAT PTAT__par VSS 3.9542032e-14
RT0 T0 T0__par 1253.0071
CT0 T0__par VSS 5.5998739e-14
RT1 T1 T1__par 1214.9021
CT1 T1__par VSS 5.5179431e-14
RT2 T2 T2__par 1176.8024
CT2 T2__par VSS 5.4360123e-14
RT3 T3 T3__par 1138.7083
CT3 T3__par VSS 5.3540815e-14
RT4 T4 T4__par 1100.6204
CT4 T4__par VSS 5.2721507e-14
RT5 T5 T5__par 607.3914
CT5 T5__par VSS 4.5515196e-14
RVDD VDD VDD__par 11776.8157
CVDD VDD__par VSS 1.23638547e-13
RVSS VSS VSS__par 3083.8865
CVSS VSS__par VSS 1.58058319e-13
.ends temp_core

* por_comparator -- post-layout netlist
* GENERATED by layout/postlayout.py -- do not edit.
*
* FROM THE LAYOUT: every device and its dimensions, the whole
*   topology, and first-order interconnect R/C on 15/18 nets
*   (sigma 473.0 fF). klt 0.2.0, deck gf180mcu,
*   GDS sha256 45b4b14914c4e651...
* Net names are the schematic's, restored through klt lvs's own net
*   correspondence -- match, 18/18 nets, every one paired.
*
* NOT FROM THE LAYOUT -- see layout/postlayout/AUDIT.md:
*   3 body/plate net(s) tied to the net the schematic puts
*   them on. The extraction deck's connectivity stack does not reach
*   an Nwell, a substrate ring, a bipolar base well or a MiM plate,
*   so they extract isolated and would otherwise float.
*   No ideal device: every golden device is drawn.
*
.subckt por_comparator VDD VSS IBIAS VREF BIAS_OK POR_RAW

* --- drawn devices ---
X1 TN NBG VSS VSS nfet_03v3 L=10u W=1u nf=1 ad=0.8p as=0.8p pd=3.6u ps=3.6u m=1
X2 IBIAS BIAS_OKB VSS VSS nfet_03v3 L=1u W=1u nf=1 ad=0.8p as=0.8p pd=3.6u ps=3.6u m=1
X3 N1 CMPO VSS VSS nfet_03v3 L=0.5u W=1u nf=1 ad=0.8p as=0.8p pd=3.6u ps=3.6u m=1
X4 POR_RAW N1 VSS VSS nfet_03v3 L=0.5u W=1u nf=1 ad=0.8p as=0.8p pd=3.6u ps=3.6u m=1
X5 BIAS_OKB BIAS_OK VSS VSS nfet_03v3 L=0.5u W=1u nf=1 ad=0.8p as=0.5p pd=3.6u ps=3u m=1
X6 NA SNS TN VSS nfet_03v3 L=1u W=2u nf=1 ad=1.6p as=1.6p pd=5.6u ps=5.6u m=1
X7 CMPO VREF TN VSS nfet_03v3 L=1u W=2u nf=1 ad=1.6p as=1.6p pd=5.6u ps=5.6u m=1
X8 IBIAS NBG VSS VSS nfet_03v3 L=2u W=2u nf=1 ad=1.6p as=1.6p pd=5.6u ps=5.6u m=1
X9 IBIAS BIAS_OK NBG VSS nfet_03v3 L=0.5u W=2u nf=1 ad=1.6p as=1.6p pd=5.6u ps=5.6u m=1
X10 NBG BIAS_OKB VSS VSS nfet_03v3 L=0.5u W=2u nf=1 ad=1.6p as=1.6p pd=5.6u ps=5.6u m=1
X11 CMPO BIAS_OKB VSS VSS nfet_03v3 L=1u W=2u nf=1 ad=1.6p as=1.6p pd=5.6u ps=5.6u m=1
X12 SNSB N1 VSS VSS nfet_03v3 L=0.5u W=10u nf=1 ad=8p as=8p pd=21.6u ps=21.6u m=1
X13 N1 CMPO VDD VDD pfet_03v3 L=0.5u W=2u nf=1 ad=1.6p as=1.6p pd=5.6u ps=5.6u m=1
X14 POR_RAW N1 VDD VDD pfet_03v3 L=0.5u W=2u nf=1 ad=1.6p as=1.6p pd=5.6u ps=5.6u m=1
X15 NA NA VDDA VDD pfet_03v3 L=1u W=4u nf=1 ad=3.2p as=3.2p pd=9.6u ps=9.6u m=1
X16 CMPO NA VDDA VDD pfet_03v3 L=1u W=4u nf=1 ad=3.2p as=3.2p pd=9.6u ps=9.6u m=1
X17 VDDA BIAS_OKB VDD VDD pfet_03v3 L=0.5u W=4u nf=1 ad=3.2p as=3.2p pd=9.6u ps=9.6u m=1
X18 BIAS_OKB BIAS_OK VDD VDD pfet_03v3 L=0.5u W=2u nf=1 ad=1.6p as=1p pd=5.6u ps=5u m=1
X19 SNS VDD VSS ppolyf_u_3k r_width=2u r_length=7897.44u
X20 SNSB SNS VSS ppolyf_u_3k r_width=2u r_length=6769.23u
X21 VSS SNSB VSS ppolyf_u_3k r_width=2u r_length=775u

R_10 SNS SNS__par 1410.6865
C_10 SNS__par VSS 2.5945833e-14
R_12 NBG NBG__par 1516.9554
C_12 NBG__par VSS 2.1326008e-14
R_14 SNSB SNSB__par 1330.8009
C_14 SNSB__par VSS 1.7531363e-14
R_3 VDDA VDDA__par 1263.8244
C_3 VDDA__par VSS 1.4679011e-14
R_4 NA NA__par 1384.846
C_4 NA__par VSS 1.5868526e-14
R_5 CMPO CMPO__par 1382.1249
C_5 CMPO__par VSS 1.7766709e-14
R_7 N1 N1__par 1437.8825
C_7 N1__par VSS 1.7866109e-14
R_9 TN TN__par 1261.1261
C_9 TN__par VSS 1.3588667e-14
RBIAS_OK BIAS_OK BIAS_OK__par 1452.1675
CBIAS_OK BIAS_OK__par VSS 1.5015489e-14
RBIAS_OKB BIAS_OKB BIAS_OKB__par 1631.1837
CBIAS_OKB BIAS_OKB__par VSS 2.1659338e-14
RIBIAS IBIAS IBIAS__par 1265.9835
CIBIAS IBIAS__par VSS 1.5551286e-14
RPOR_RAW POR_RAW POR_RAW__par 1260.5254
CPOR_RAW POR_RAW__par VSS 1.3389027e-14
RVDD VDD VDD__par 74.7605
CVDD VDD__par VSS 5.225586e-14
RVREF VREF VREF__par 1314.9134
CVREF VREF__par VSS 1.1576327e-14
RVSS VSS VSS__par 129.7465
CVSS VSS__par VSS 1.989616e-13
.ends por_comparator
