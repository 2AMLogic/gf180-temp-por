* Frozen netlist snapshot for record 20260811-123635-eb0f4ef
* source     : sim/bias-core-designer-check/testbench-postlayout/tb_bias_core.spice
* sha256     : 8fd6f74d1af05ef3df85f9f57bc5b36f84bfdcf21d7b2dfe24e4256ddf949374
* This is a verbatim copy taken at record time. Do not edit.
* tb_bias_core -- GENERATED by sim/build_tb.py
* Do not edit. Sources:
*   sim/bias-core-designer-check/testbench/stimulus.spice
*   layout/postlayout/bias_core.spice  (sha256 2a04a0b6f0f58318c2bcda10c2d03b421fa9b76452f97d22ed234ac0bcdc44bd)
* Regenerate with:
*   python3 sim/build_tb.py

* bias-core-designer-check -- stimulus half of the testbench fragment.
*
* The other half is a verbatim copy of design/netlist/bias_core.spice,
* appended by sim/build_tb.py to produce tb_bias_core.spice. Edit THIS file
* (or the schematic), never the generated fragment.
*
* Netlist FRAGMENT: no .include / .lib / .temp / .control / .end -- the
* harness owns those. Parameters it supplies: vdd_val, vdd_nom, temp_c.
*
* bias_core has NO enable pin and no off state, so there is only one Iq
* state to measure: the always-on one. That is exactly the state
* spec/target-spec.md SS5 rule 1 quotes por-iq in, which is why this record
* can charge the whole of branch 1's supply current to that row without any
* apportionment argument.
*
* FOUR branches, all in one transient so every number below comes from one
* corner point:
*
*   1. xst   STATIC DUT at this point's vdd_val, DC supply. Supplies the
*            settled numbers (VREF, IBIAS, Iq, BIAS_OK) AND the degenerate-
*            state check: this deck does NOT use `uic`, so ngspice solves a
*            real operating point at t=0 with this branch already at full
*            rail. `vref_op_v` samples that solution. A bandgap loop has a
*            zero-current solution as well as its intended one, and the DC
*            solver is free to land on it -- design/temp_core.md records
*            exactly that happening to #9's first revision. If it lands
*            there here, vref_op_v reads ~0 and the check fails.
*
*   2. xs    SLOW ramp (0 -> vdd_val in 500 us), then held. Supplies settling
*            time, the core's dropout voltage, and BIAS_OK's assertion point
*            measured against the reference's OWN settled value at the same
*            corner (branch 1's), not against a hardcoded target.
*
*   3. xf    FAST ramp: 0 -> vdd_val in 3.63 us, i.e. exactly 1.0 V/us at
*            the 3.63 V rail -- spec/target-spec.md#por-ramp-rate's ratified
*            FAST LIMIT, not beyond it. This is where a reference that is
*            still settling could let the POR comparator release early, so
*            both ramps carry the release guard and the false-valid integral
*            below.
*
*   4. xb    BROWNOUT: settle, dip to 0.5 V (rail low but nodes still
*            charged -- the classic latch trap), recover, then collapse to
*            0 V and recover again. `bo_*_ppm` compare the reference before
*            and after each event.
*
* THE FALSE-VALID INTEGRAL (Bfos / Bfof) is the correctness statement about
* BIAS_OK: it is 1 whenever BIAS_OK is a valid high AND the reference is more
* than 100 mV BELOW its settled value at this corner, and the record
* integrates it into a time. Zero means "BIAS_OK was never a valid high on a
* reference that was low enough to matter".
*
* It is deliberately ONE-SIDED, matching the settle detector it is testing.
* A reference that is HIGH raises por_comparator's threshold and therefore
* delays release, which spec/target-spec.md#por-reset-pulse explicitly does
* not bound ("no maximum specified in wave 1"). A reference that is LOW
* lowers the threshold and releases early, below the ratified
* spec/target-spec.md#por-vth-rise minimum. Only the second is a correctness
* failure, and only the second is counted here.
*
* THE RELEASE GUARD (Brels / Brelf) is the load-bearing measurement for
* BIAS_OK. por_comparator releases when its divided rail reaches VREF, i.e.
* when VDD >= VREF * (RTOP+RBOT)/RBOT = 2.16667*VREF
* (design/por_comparator.md, "Device sizing"), and that decision only becomes
* authoritative once BIAS_OK is high (DR-005 startup ordering, step 4). The
* B-source therefore reports -1 whenever BIAS_OK is not a valid high and
* (VDD - 2.16667*VREF) when it is; its first zero crossing is the rail at
* which the assembled block WOULD release. Checking that against
* spec/target-spec.md#por-vth-rise's 2.47 V minimum is a direct test of
* "BIAS_OK never goes valid early enough to matter", which is stronger than
* timing BIAS_OK against VREF in isolation.
*
* The 2.16667 ratio is por_comparator's committed divider ratio, quoted here
* as a constant rather than simulated: this record is about bias_core, and
* wiring the real comparator in would make it a top-level record instead
* (that is #14's job). sim/bias-core-ibias-sharing/ is the one place this
* issue does instantiate the neighbours, and only to check the shared IBIAS
* net, not thresholds.

* ---- 1. static DUT, full rail, IBIAS metered -------------------------
* The IBIAS load is a diode-connected nfet_03v3 2u/2u -- por_comparator's
* own XMBD (design/por_comparator.md, "Enable path"), so the pin sees the
* load it will actually drive in the reset-asserted state.
vsupst vddst 0 dc {vdd_val}
vibst  nibst ibiasst dc 0
xst    vddst 0 nibst vrefst bias_okst bias_core
xmldst ibiasst ibiasst 0 0 nfet_03v3 L=2u W=2u nf=1 m=1

* ---- 2. slow ramp ----------------------------------------------------
vsups vdds 0 PWL(0 0 500u {vdd_val} 2m {vdd_val})
vibs  nibs ibiass dc 0
xs    vdds 0 nibs vrefs bias_oks bias_core
xmlds ibiass ibiass 0 0 nfet_03v3 L=2u W=2u nf=1 m=1
Bes  es  0 v = abs(v(vrefs) - v(vrefst))
Brels rels 0 v = (v(bias_oks) > 0.5*v(vdds)) ? (v(vdds) - 2.16667*v(vrefs)) : -1
Brr9s rr9s 0 v = v(vrefs) - 0.9*v(vrefst)
Bfos fos 0 v = ((v(bias_oks) > 0.5*v(vdds)) ? 1 : 0) * ((v(vrefst)-v(vrefs) > 0.1) ? 1 : 0)

* ---- 3. fast ramp ----------------------------------------------------
vsupf vddf 0 PWL(0 0 3.63u {vdd_val} 2m {vdd_val})
vibf  nibf ibiasf dc 0
xf    vddf 0 nibf vreff bias_okf bias_core
xmldf ibiasf ibiasf 0 0 nfet_03v3 L=2u W=2u nf=1 m=1
Bef  ef  0 v = abs(v(vreff) - v(vrefst))
Brelf relf 0 v = (v(bias_okf) > 0.5*v(vddf)) ? (v(vddf) - 2.16667*v(vreff)) : -1
Bfof fof 0 v = ((v(bias_okf) > 0.5*v(vddf)) ? 1 : 0) * ((v(vrefst)-v(vreff) > 0.1) ? 1 : 0)

* ---- 4. brownout: shallow dip, then full collapse --------------------
vsupb vddb 0 PWL(0 0 100u {vdd_val} 400u {vdd_val} 410u 0.5 550u 0.5
+ 560u {vdd_val} 950u {vdd_val} 960u 0 1100u 0 1110u {vdd_val} 2m {vdd_val})
vibb  nibb ibiasb dc 0
xb    vddb 0 nibb vrefb bias_okb bias_core
xmldb ibiasb ibiasb 0 0 nfet_03v3 L=2u W=2u nf=1 m=1
Bfob fob 0 v = ((v(bias_okb) > 0.5*v(vddb)) ? 1 : 0) * ((v(vrefst)-v(vrefb) > 0.1) ? 1 : 0)

* bias_core -- post-layout netlist
* GENERATED by layout/postlayout.py -- do not edit.
*
* FROM THE LAYOUT: every device and its dimensions, the whole
*   topology, and first-order interconnect R/C on 47/54 nets
*   (sigma 1920.0 fF). klt 0.2.0, deck gf180mcu,
*   GDS sha256 6d6236d05ae0cd82...
* Net names are the schematic's, restored through klt lvs's own net
*   correspondence -- match, 54/54 nets, every one paired.
*
* NOT FROM THE LAYOUT -- see layout/postlayout/AUDIT.md:
*   7 body/plate net(s) tied to the net the schematic puts
*   them on. The extraction deck's connectivity stack does not reach
*   an Nwell, a substrate ring, a bipolar base well or a MiM plate,
*   so they extract isolated and would otherwise float.
*   No ideal device: every golden device is drawn.
*
.subckt bias_core VDD VSS IBIAS VREF BIAS_OK

* --- drawn devices ---
X1 VDD VDD KS1 VSS nfet_03v3 L=8u W=1u nf=1 ad=0.8p as=0.8p pd=3.6u ps=3.6u m=1
X2 KS1 KS1 KS2 VSS nfet_03v3 L=8u W=1u nf=1 ad=0.8p as=0.8p pd=3.6u ps=3.6u m=1
X3 KS2 KS2 KS3 VSS nfet_03v3 L=8u W=1u nf=1 ad=0.8p as=0.8p pd=3.6u ps=3.6u m=1
X4 KS3 KS3 KS4 VSS nfet_03v3 L=8u W=1u nf=1 ad=0.8p as=0.8p pd=3.6u ps=3.6u m=1
X5 KS4 KS4 NKG VSS nfet_03v3 L=8u W=1u nf=1 ad=0.8p as=0.8p pd=3.6u ps=3.6u m=1
X6 PG NKG VSS VSS nfet_03v3 L=4u W=1u nf=1 ad=0.8p as=0.8p pd=3.6u ps=3.6u m=1
X7 NBG NBG VSS VSS nfet_03v3 L=4u W=2u nf=1 ad=1.6p as=1.6p pd=5.6u ps=5.6u m=1
X8 PB NBG VSS VSS nfet_03v3 L=4u W=2u nf=1 ad=1.6p as=1.6p pd=5.6u ps=5.6u m=1
X9 NKM NKM VSS VSS nfet_03v3 L=4u W=2u nf=1 ad=1.6p as=1.6p pd=5.6u ps=5.6u m=1
X10 NOKL NOKL VSS VSS nfet_03v3 L=4u W=2u nf=1 ad=1.6p as=1.6p pd=5.6u ps=5.6u m=1
X11 NOKO NOKL VSS VSS nfet_03v3 L=4u W=2u nf=1 ad=1.6p as=1.6p pd=5.6u ps=5.6u m=1
X12 NOKO NKG VSS VSS nfet_03v3 L=1u W=2u nf=1 ad=1.6p as=1.6p pd=5.6u ps=5.6u m=1
X13 NOKX NOKO VSS VSS nfet_03v3 L=4u W=2u nf=1 ad=1.6p as=1.6p pd=5.6u ps=5.6u m=1
X14 N1 N1 VSS VSS nfet_03v3 L=8u W=4u nf=1 ad=3.2p as=3.2p pd=9.6u ps=9.6u m=1
X15 N2 N1 VSS VSS nfet_03v3 L=8u W=4u nf=1 ad=3.2p as=3.2p pd=9.6u ps=9.6u m=1
X16 BIAS_OK NOKX VSS VSS nfet_03v3 L=0.5u W=4u nf=1 ad=3.2p as=3.2p pd=9.6u ps=9.6u m=1
X17 PG N2 VSS VSS nfet_03v3 L=8u W=8u nf=1 ad=6.4p as=6.4p pd=17.6u ps=17.6u m=1
X18 NKG NKM VSS VSS nfet_03v3 L=4u W=8u nf=1 ad=6.4p as=6.4p pd=17.6u ps=17.6u m=1
X19 NKM PB VDD VDD pfet_03v3 L=4u W=1u nf=1 ad=0.8p as=0.8p pd=3.6u ps=3.6u m=1
X20 TOK PB VDD VDD pfet_03v3 L=4u W=1u nf=1 ad=0.8p as=0.8p pd=3.6u ps=3.6u m=1
X21 NOKX PB VDD VDD pfet_03v3 L=4u W=1u nf=1 ad=0.8p as=0.8p pd=3.6u ps=3.6u m=1
X22 BIAS_OK NOKX VDD VDD pfet_03v3 L=4u W=1u nf=1 ad=0.8p as=0.8p pd=3.6u ps=3.6u m=1
X23 NBG PG VDD VDD pfet_03v3 L=4u W=2u nf=1 ad=1.6p as=1.6p pd=5.6u ps=5.6u m=1
X24 PB PB VDD VDD pfet_03v3 L=4u W=2u nf=1 ad=1.6p as=1.6p pd=5.6u ps=5.6u m=1
X25 NT PB VDD VDD pfet_03v3 L=4u W=2u nf=1 ad=1.6p as=1.6p pd=5.6u ps=5.6u m=1
X26 PG PB VDD VDD pfet_03v3 L=4u W=2u nf=1 ad=1.6p as=1.6p pd=5.6u ps=5.6u m=1
X27 NA PG VDD VDD pfet_03v3 L=4u W=8u nf=1 ad=6.4p as=6.4p pd=17.6u ps=17.6u m=1
X28 NBTOP PG VDD VDD pfet_03v3 L=4u W=8u nf=1 ad=6.4p as=6.4p pd=17.6u ps=17.6u m=1
X29 VREF PG VDD VDD pfet_03v3 L=4u W=8u nf=1 ad=6.4p as=6.4p pd=17.6u ps=17.6u m=1
X30 NOKO NA TOK VDD pfet_03v3 L=4u W=8u nf=1 ad=6.4p as=6.4p pd=17.6u ps=17.6u m=1
X31 NOKL NBTOP TOK VDD pfet_03v3 L=4u W=8u nf=1 ad=6.4p as=6.4p pd=17.6u ps=17.6u m=1
X32 N1 NA NT VDD pfet_03v3 L=4u W=16u nf=1 ad=12.8p as=12.8p pd=33.6u ps=33.6u m=1
X33 N2 NB NT VDD pfet_03v3 L=4u W=16u nf=1 ad=12.8p as=12.8p pd=33.6u ps=33.6u m=1
X34 IBIAS PB VDD VDD pfet_03v3 L=4u W=40u nf=1 ad=32p as=32p pd=81.6u ps=81.6u m=1
X35 VSS VSS EC pnp_10p00x10p00
X36 VSS VSS EC pnp_10p00x10p00
X37 VSS VSS EC pnp_10p00x10p00
X38 VSS VSS EC pnp_10p00x10p00
X39 VSS VSS NA pnp_10p00x10p00
X40 VSS VSS EC pnp_10p00x10p00
X41 VSS VSS ER pnp_10p00x10p00
X42 VSS VSS EC pnp_10p00x10p00
X43 VSS VSS EC pnp_10p00x10p00
X44 VSS VSS EC pnp_10p00x10p00
X45 NOKX VDD cap_mim_2f0_m3m4_noshield c_width=6u c_length=6u
X46 NZ PG cap_mim_2f0_m3m4_noshield c_width=20u c_length=20u
X47 VREF XR2__1 VSS ppolyf_u_3k r_width=2u r_length=256.5u
X48 XR2__2 XR2__1 VSS ppolyf_u_3k r_width=2u r_length=256.5u
X49 XR2__2 XR2__3 VSS ppolyf_u_3k r_width=2u r_length=256.5u
X50 XR2__4 XR2__3 VSS ppolyf_u_3k r_width=2u r_length=256.5u
X51 XR2__4 XR2__5 VSS ppolyf_u_3k r_width=2u r_length=256.5u
X52 XR2__6 XR2__5 VSS ppolyf_u_3k r_width=2u r_length=256.5u
X53 XR2__6 XR2__7 VSS ppolyf_u_3k r_width=2u r_length=256.5u
X54 XR2__8 XR2__7 VSS ppolyf_u_3k r_width=2u r_length=256.5u
X55 XR2__8 XR2__9 VSS ppolyf_u_3k r_width=2u r_length=256.5u
X56 XR2__10 XR2__9 VSS ppolyf_u_3k r_width=2u r_length=256.5u
X57 XR2__10 XR2__11 VSS ppolyf_u_3k r_width=2u r_length=256.5u
X58 XR2__12 XR2__11 VSS ppolyf_u_3k r_width=2u r_length=256.5u
X59 XR2__12 XR2__13 VSS ppolyf_u_3k r_width=2u r_length=256.5u
X60 XR2__14 XR2__13 VSS ppolyf_u_3k r_width=2u r_length=256.5u
X61 XR2__14 XR2__15 VSS ppolyf_u_3k r_width=2u r_length=256.5u
X62 ER XR2__15 VSS ppolyf_u_3k r_width=2u r_length=256.5u
X63 NZ XRZ__1 VSS ppolyf_u_3k r_width=2u r_length=254u
X64 XRZ__2 XRZ__1 VSS ppolyf_u_3k r_width=2u r_length=254u
X65 XRZ__2 XRZ__3 VSS ppolyf_u_3k r_width=2u r_length=254u
X66 N2 XRZ__3 VSS ppolyf_u_3k r_width=2u r_length=254u
X67 NB XR1__1 VSS ppolyf_u_3k r_width=2u r_length=175u
X68 EC XR1__1 VSS ppolyf_u_3k r_width=2u r_length=175u
X69 NBTOP XRT__1 VSS ppolyf_u_3k r_width=2u r_length=8.75u
X70 NB XRT__1 VSS ppolyf_u_3k r_width=2u r_length=8.75u

R_10 N1 N1__par 4967.8583
C_10 N1__par VSS 5.978126e-14
R_11 N2 N2__par 7855.0506
C_11 N2__par VSS 8.4779094e-14
R_12 NKM NKM__par 4876.8874
C_12 NKM__par VSS 5.7923066e-14
R_13 TOK TOK__par 4690.5254
C_13 TOK__par VSS 5.2350545e-14
R_14 NOKO NOKO__par 4792.4183
C_14 NOKO__par VSS 5.9161863e-14
R_15 NOKL NOKL__par 4883.997
C_15 NOKL__par VSS 6.0794305e-14
R_16 NOKX NOKX__par 4848.4085
C_16 NOKX__par VSS 5.9751918e-14
R_17 KS1 KS1__par 4818.8511
C_17 KS1__par VSS 5.4330567e-14
R_18 KS2 KS2__par 4819.3911
C_18 KS2__par VSS 5.4548635e-14
R_19 KS3 KS3__par 4819.931
C_19 KS3__par VSS 5.4766704e-14
R_20 KS4 KS4__par 4820.471
C_20 KS4__par VSS 5.4984773e-14
R_21 NKG NKG__par 4848.0503
C_21 NKG__par VSS 5.7785044e-14
R_23 NB NB__par 7667.0394
C_23 NB__par VSS 7.6118691e-14
R_24 EC EC__par 2791.7858
C_24 EC__par VSS 7.4268842e-14
R_25 NZ NZ__par 2787.2554
C_25 NZ__par VSS 2.545538e-14
R_27 XRZ__2 XRZ__2__par 18.25
C_27 XRZ__2__par VSS 1.8067e-15
R_28 XR2__14 XR2__14__par 18.25
C_28 XR2__14__par VSS 1.8067e-15
R_29 XR2__12 XR2__12__par 18.25
C_29 XR2__12__par VSS 1.8067e-15
R_3 PG PG__par 5084.0134
C_3 PG__par VSS 6.8147207e-14
R_30 XR2__10 XR2__10__par 18.25
C_30 XR2__10__par VSS 1.8067e-15
R_31 XR2__8 XR2__8__par 18.25
C_31 XR2__8__par VSS 1.8067e-15
R_32 XR2__6 XR2__6__par 18.25
C_32 XR2__6__par VSS 1.8067e-15
R_33 XR2__4 XR2__4__par 18.25
C_33 XR2__4__par VSS 1.8067e-15
R_34 XR2__2 XR2__2__par 18.25
C_34 XR2__2__par VSS 1.8067e-15
R_35 NA NA__par 8008.5898
C_35 NA__par VSS 8.7590412e-14
R_36 ER ER__par 2787.674
C_36 ER__par VSS 3.3170077e-14
R_37 XRT__1 XRT__1__par 18.25
C_37 XRT__1__par VSS 1.8067e-15
R_4 NBTOP NBTOP__par 7796.7657
C_4 NBTOP__par VSS 7.8325844e-14
R_43 XR1__1 XR1__1__par 18.25
C_43 XR1__1__par VSS 1.8067e-15
R_44 XRZ__3 XRZ__3__par 18.25
C_44 XRZ__3__par VSS 1.8067e-15
R_45 XRZ__1 XRZ__1__par 18.25
C_45 XRZ__1__par VSS 1.8067e-15
R_46 XR2__13 XR2__13__par 18.25
C_46 XR2__13__par VSS 1.8067e-15
R_47 XR2__11 XR2__11__par 18.25
C_47 XR2__11__par VSS 1.8067e-15
R_48 XR2__1 XR2__1__par 18.25
C_48 XR2__1__par VSS 1.8067e-15
R_49 XR2__3 XR2__3__par 18.25
C_49 XR2__3__par VSS 1.8067e-15
R_50 XR2__5 XR2__5__par 18.25
C_50 XR2__5__par VSS 1.8067e-15
R_51 XR2__7 XR2__7__par 18.25
C_51 XR2__7__par VSS 1.8067e-15
R_52 XR2__9 XR2__9__par 18.25
C_52 XR2__9__par VSS 1.8067e-15
R_53 XR2__15 XR2__15__par 18.25
C_53 XR2__15__par VSS 1.8067e-15
R_6 NBG NBG__par 4871.7578
C_6 NBG__par VSS 5.5851412e-14
R_7 PB PB__par 5396.0003
C_7 PB__par VSS 7.9168117e-14
R_9 NT NT__par 4684.5858
C_9 NT__par VSS 4.9951788e-14
RBIAS_OK BIAS_OK BIAS_OK__par 4679.0384
CBIAS_OK BIAS_OK__par VSS 4.7753184e-14
RIBIAS IBIAS IBIAS__par 4663.4113
CIBIAS IBIAS__par VSS 4.1483963e-14
RVDD VDD VDD__par 371.4414
CVDD VDD__par VSS 1.29011679e-13
RVREF VREF VREF__par 7695.5815
CVREF VREF__par VSS 7.3513489e-14
RVSS VSS VSS__par 145.0301
CVSS VSS__par VSS 2.53093198e-13
.ends bias_core
