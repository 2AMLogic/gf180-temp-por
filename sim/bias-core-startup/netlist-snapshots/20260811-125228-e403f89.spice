* Frozen netlist snapshot for record 20260811-125228-e403f89
* source     : sim/bias-core-startup/testbench-postlayout/tb_bias_core_startup.spice
* sha256     : 1820d60d62f9be5167826ce8881b94279334916c9f1a805596b7df33d7d4b8e4
* This is a verbatim copy taken at record time. Do not edit.
* tb_bias_core_startup -- GENERATED by sim/build_tb.py
* Do not edit. Sources:
*   sim/bias-core-startup/testbench/stimulus.spice
*   layout/postlayout/bias_core.spice  (sha256 2a04a0b6f0f58318c2bcda10c2d03b421fa9b76452f97d22ed234ac0bcdc44bd)
* Regenerate with:
*   python3 sim/build_tb.py

* bias-core-startup -- stimulus half of the testbench fragment.
*
* The other half is a verbatim copy of design/netlist/bias_core.spice,
* appended by sim/build_tb.py to produce tb_bias_core_startup.spice. Edit
* THIS file (or the schematic), never the generated fragment.
*
* Netlist FRAGMENT: no .include / .lib / .temp / .control / .end -- the
* harness owns those. Parameters it supplies: vdd_val, vdd_nom, temp_c.
*
* ---------------------------------------------------------------------------
* METHOD CHANGE, issue #46: this experiment was a `.dc` continuation sweep and
* is now a QUASI-STATIC TRANSIENT RAMP. Records taken before 2026-08-01 used
* the old method; the two are NOT comparable point-for-point, and the reason
* is that the old method was measuring its own convergence aid.
*
* What the old deck did, and why it had to go. It swept `vdd` with `.dc` from
* 0 to 3.63 V, letting ngspice's continuation seed each step from the previous
* step's solution, and it could only be made to converge at all by raising
* `gmin` from ngspice's default 1e-12 to 1e-9 (see the CONVERGENCE note in the
* superseded revision, `git show e47a8e0:sim/bias-core-startup/testbench/
* stimulus.spice`). GMIN is a conductance ngspice places across every device
* junction to keep the Jacobian non-singular. At 1 nS and 3.3 V of rail that
* is ~2.7 nA per junction -- and the settle comparator this experiment exists
* to test resolves a 0.247 nA imbalance between a 4.728 nA and a 4.481 nA
* branch (`../control/results.md`, the same source as the figures below). The
* comparator's own output node `NOKO` carries one junction (`XMOKC`'s drain)
* that its reference-side counterpart `NOKL` does not, so the aid injected a
* 0.563 nA DIFFERENTIAL error -- larger than the signal. That, and not the
* circuit, is what the 27-of-27 `BIAS_OK` failure in record
* `20260801-111049-bc599be` measured.
*
* The controlled experiment is COMMITTED, in `../control/`: one deck, one
* variable (`.options gmin`), both raw ngspice logs, and the generated
* `../control/results.md` that every number in this comment block is
* transcribed from. Re-run it with
* `python3 sim/bias-core-startup/control/run_gmin_control.py`. The one-line
* version is that at tt/-40 C, VDD = 3.3 V, a plain `op` gives
* V(NOKO) = 0.605 V and BIAS_OK = 1.54 uV at gmin = 1e-9, and
* V(NOKO) = 1.643 V and BIAS_OK = 3.29999985 V at ngspice's default gmin,
* with nothing else changed.
*
* The `.dc` sweep cannot simply be re-run at the default gmin: it does not
* converge there at any of the 27 corner/temperature combinations (all 27 hit
* the harness's 300 s per-point timeout). A DC continuation is the wrong tool
* for a circuit whose operating point below ~1 V of rail has every branch near
* cutoff at once. A transient does not need the crutch: it integrates through
* that region instead of solving it standing still, and it converges at every
* one of the 81 points here at ngspice's default gmin.
*
* WHY A SLOW RAMP AND NOT A DC SWEEP -- the same argument
* sim/por-output-chain-floor/ already makes in this repo for the same reason.
* A transient ramp is the stronger evidence anyway: it is a trajectory a real
* rail can actually take, rather than a sequence of independent DC solutions
* stitched together by a solver heuristic.
*
* ---------------------------------------------------------------------------
* WHAT "QUASI-STATIC" MEANS HERE, AND HOW THIS DECK PROVES IT
*
* The claim the experiment needs is the RAMP-RATE-INDEPENDENT one: where does
* a continuously rising rail leave this cell, in the limit where the rail is
* slow compared with the loop. design/bias_core.md measures the loop's
* settling at 10.9-33.4 us, so at this deck's 121 V/s the loop is never more
* than ~1.3-4.0 mV of rail behind -- 0.1 % of the rail. That is an argument,
* not evidence, so the deck also MEASURES rate-independence: `xqf` is a third
* DUT on a 4x faster ramp (484 V/s), and `qs_rate_delta_mv` is the difference
* in the rail at which BIAS_OK asserts between the two. Two rates a factor of
* four apart agreeing to within tens of millivolts is the statement that both
* are in the quasi-static limit; a rate-dependent result would show up there
* first. Both rates sit 3-4 decades below the 0.36 V/us boundary at which
* design/bias_core.md measures the loop starting to lag, and inside the
* ratified spec/target-spec.md#por-ramp-rate envelope (1 V/s ... 1 V/us) --
* whose full sweep remains #14's chartered row, deliberately not pre-empted
* here.
*
* THREE DUTS, one `tran`, the multi-DUT idiom this repo already uses in
* sim/bias-core-designer-check/ and sim/por-output-chain-floor/:
*
*   xqs  0 -> 3.63 V over 30 ms, then flat      the primary quasi-static cold
*        (121 V/s)                              start. Every branch-tracking,
*                                               ordering and release-rail
*                                               measurement is taken here.
*   xqf  0 -> 3.63 V over 7.5 ms, then flat     the same experiment 4x faster,
*        (484 V/s)                              used ONLY to demonstrate that
*                                               the primary result is in the
*                                               quasi-static limit.
*   xbo  the xqs ramp, then a FULL collapse to  the brownout-restart branch:
*        0 V and 3 ms of dead rail, then the    whether the cell restarts onto
*        same quasi-static ramp again           the same branch, and whether
*                                               BIAS_OK reads a stale valid
*                                               while the rail is down.
*
* The brownout branch is the second half of the cross-check issue #43's
* acceptance criteria asked for ("a transient cold-start + brownout-restart
* experiment") and #46 inherited. sim/bias-core-designer-check/ already covers
* collapse-and-restart on a FAST rail (its `t_bo_recover_us` / `bo_deep_ppm`);
* what is new here is that the restart is quasi-static, which is the case
* where a wrong branch has all the time it needs to establish itself.
*
* The supply axis of the PVT grid is deliberately degenerate for this
* experiment, exactly as it was for the superseded `.dc` revision: the ramp
* passes through 2.97, 3.30 and 3.63 V on its way up, so the three supply
* points of the mandated grid produce identical curves by construction and
* `vdd_val` is not referenced below. The grid is still run in full (9 process
* corners x 3 temperatures x 3 supplies = 81 ngspice invocations) because
* sim/README.md requires the full mandated PVT matrix on every recorded result
* and a redundant supply axis is not grounds for a --subset-reason; the record
* groups results by the 27 distinct (process, temperature) combinations, each
* backed by three bit-identical supply replicates.
*
* IBIAS carries the same consumer-diode replica load the other two bias_core
* experiments use (temp_core's XMBD 4u/2u and por_comparator's XMBD 2u/2u,
* verbatim from the exported netlists), so the ramp sees the loading the
* shared node actually carries.
*
* The DEAD-state half of the startup claim -- that the degenerate zero-current
* solution is not stable anywhere on the grid -- is covered separately, and
* more strongly, by sim/bias-core-designer-check/'s `vref_op_v`, which seeds
* the DC solve IN that state at all 81 points.

* ---- xqs: primary quasi-static cold start, 121 V/s -------------------------
vqs vddq 0 PWL(0 0 30m 3.63 70m 3.63)
vibq nibq ibiasq dc 0
xqs vddq 0 nibq vrefq bias_okq bias_core
xldtq ibiasq ibiasq 0 0 nfet_03v3 L=2u W=4u nf=1 m=1
xldcq ibiasq ibiasq 0 0 nfet_03v3 L=2u W=2u nf=1 m=1

* The release guard, verbatim in form from sim/bias-core-designer-check/: the
* rail at which the ASSEMBLED block would actually release, i.e. where
* (BIAS_OK is a valid high) and (VDD >= 2.16667*VREF, por_comparator's ratified
* divider ratio) first hold together. -1 while BIAS_OK is not valid, so a
* rising zero-crossing is the release event. This is the measurement that
* carries spec/target-spec.md#por-vth-rise, and it is reference-referred rather
* than rail-referred: a BIAS_OK that went valid early against a still-rising
* reference shows up here as a release rail below 2.47 V.
Brelq relq 0 v = (v(bias_okq) > 0.5*v(vddq)) ? (v(vddq) - 2.16667*v(vrefq)) : -1

* ---- xqf: the same cold start 4x faster, 484 V/s ---------------------------
* Present only to measure rate-independence (`qs_rate_delta_mv`).
vqf vddf 0 PWL(0 0 7.5m 3.63 70m 3.63)
vibf nibf ibiasf dc 0
xqf vddf 0 nibf vreff bias_okf bias_core
xldtf ibiasf ibiasf 0 0 nfet_03v3 L=2u W=4u nf=1 m=1
xldcf ibiasf ibiasf 0 0 nfet_03v3 L=2u W=2u nf=1 m=1

* ---- xbo: quasi-static cold start, full collapse, quasi-static restart -----
* 3 ms of dead rail at 0 V, with the rail source itself holding 0 V, so every
* internal node discharges into it. How cold the cell actually gets is
* MEASURED rather than asserted: `vref_bo_dip_v` samples VREF two-thirds of
* the way through the window (35 ms, i.e. 2 ms into the 3 ms), and the record
* reports 0.016...0.518 V there -- so at the slowest corner (`ss`/-40 C) the
* cell is substantially, not completely, discharged when the restart begins.
* An earlier revision of this comment claimed the window was "~4 time
* constants ... so the restart starts from a genuinely cold cell"; the
* measurement does not support that at every corner, and the claim is not
* needed here. State the limit instead: a partly-discharged cell is biased
* toward the branch it was already on, so `vref_bo_end_delta_ppm` agreeing to
* better than 1 ppm says the restart is REPEATABLE, not that no second branch
* is reachable. The stronger statement -- that the degenerate zero-current
* solution is not stable anywhere on the grid -- is made where it belongs, by
* sim/bias-core-designer-check/'s `vref_op_v`, which SEEDS the DC solve in
* that state at all 81 points (see the note at the end of this header).
vbo vddb 0 PWL(0 0 30m 3.63 32m 3.63 33m 0 36m 0 66m 3.63 70m 3.63)
vibb nibb ibiasb dc 0
xbo vddb 0 nibb vrefb bias_okb bias_core
xldtb ibiasb ibiasb 0 0 nfet_03v3 L=2u W=4u nf=1 m=1
xldcb ibiasb ibiasb 0 0 nfet_03v3 L=2u W=2u nf=1 m=1

* bias_core -- post-layout netlist
* GENERATED by layout/postlayout.py -- do not edit.
*
* FROM THE LAYOUT: every device and its dimensions, the whole
*   topology, and first-order interconnect R/C on 47/54 nets
*   (sigma 1920.0 fF). klt 0.2.0, deck gf180mcu,
*   GDS sha256 6d6236d05ae0cd82...
* Net names are the schematic's, restored through klt lvs's own net
*   correspondence -- match, 54/54 nets, every one paired.
*
* NOT FROM THE LAYOUT -- see layout/postlayout/AUDIT.md:
*   7 body/plate net(s) tied to the net the schematic puts
*   them on. The extraction deck's connectivity stack does not reach
*   an Nwell, a substrate ring, a bipolar base well or a MiM plate,
*   so they extract isolated and would otherwise float.
*   No ideal device: every golden device is drawn.
*
.subckt bias_core VDD VSS IBIAS VREF BIAS_OK

* --- drawn devices ---
X1 VDD VDD KS1 VSS nfet_03v3 L=8u W=1u nf=1 ad=0.8p as=0.8p pd=3.6u ps=3.6u m=1
X2 KS1 KS1 KS2 VSS nfet_03v3 L=8u W=1u nf=1 ad=0.8p as=0.8p pd=3.6u ps=3.6u m=1
X3 KS2 KS2 KS3 VSS nfet_03v3 L=8u W=1u nf=1 ad=0.8p as=0.8p pd=3.6u ps=3.6u m=1
X4 KS3 KS3 KS4 VSS nfet_03v3 L=8u W=1u nf=1 ad=0.8p as=0.8p pd=3.6u ps=3.6u m=1
X5 KS4 KS4 NKG VSS nfet_03v3 L=8u W=1u nf=1 ad=0.8p as=0.8p pd=3.6u ps=3.6u m=1
X6 PG NKG VSS VSS nfet_03v3 L=4u W=1u nf=1 ad=0.8p as=0.8p pd=3.6u ps=3.6u m=1
X7 NBG NBG VSS VSS nfet_03v3 L=4u W=2u nf=1 ad=1.6p as=1.6p pd=5.6u ps=5.6u m=1
X8 PB NBG VSS VSS nfet_03v3 L=4u W=2u nf=1 ad=1.6p as=1.6p pd=5.6u ps=5.6u m=1
X9 NKM NKM VSS VSS nfet_03v3 L=4u W=2u nf=1 ad=1.6p as=1.6p pd=5.6u ps=5.6u m=1
X10 NOKL NOKL VSS VSS nfet_03v3 L=4u W=2u nf=1 ad=1.6p as=1.6p pd=5.6u ps=5.6u m=1
X11 NOKO NOKL VSS VSS nfet_03v3 L=4u W=2u nf=1 ad=1.6p as=1.6p pd=5.6u ps=5.6u m=1
X12 NOKO NKG VSS VSS nfet_03v3 L=1u W=2u nf=1 ad=1.6p as=1.6p pd=5.6u ps=5.6u m=1
X13 NOKX NOKO VSS VSS nfet_03v3 L=4u W=2u nf=1 ad=1.6p as=1.6p pd=5.6u ps=5.6u m=1
X14 N1 N1 VSS VSS nfet_03v3 L=8u W=4u nf=1 ad=3.2p as=3.2p pd=9.6u ps=9.6u m=1
X15 N2 N1 VSS VSS nfet_03v3 L=8u W=4u nf=1 ad=3.2p as=3.2p pd=9.6u ps=9.6u m=1
X16 BIAS_OK NOKX VSS VSS nfet_03v3 L=0.5u W=4u nf=1 ad=3.2p as=3.2p pd=9.6u ps=9.6u m=1
X17 PG N2 VSS VSS nfet_03v3 L=8u W=8u nf=1 ad=6.4p as=6.4p pd=17.6u ps=17.6u m=1
X18 NKG NKM VSS VSS nfet_03v3 L=4u W=8u nf=1 ad=6.4p as=6.4p pd=17.6u ps=17.6u m=1
X19 NKM PB VDD VDD pfet_03v3 L=4u W=1u nf=1 ad=0.8p as=0.8p pd=3.6u ps=3.6u m=1
X20 TOK PB VDD VDD pfet_03v3 L=4u W=1u nf=1 ad=0.8p as=0.8p pd=3.6u ps=3.6u m=1
X21 NOKX PB VDD VDD pfet_03v3 L=4u W=1u nf=1 ad=0.8p as=0.8p pd=3.6u ps=3.6u m=1
X22 BIAS_OK NOKX VDD VDD pfet_03v3 L=4u W=1u nf=1 ad=0.8p as=0.8p pd=3.6u ps=3.6u m=1
X23 NBG PG VDD VDD pfet_03v3 L=4u W=2u nf=1 ad=1.6p as=1.6p pd=5.6u ps=5.6u m=1
X24 PB PB VDD VDD pfet_03v3 L=4u W=2u nf=1 ad=1.6p as=1.6p pd=5.6u ps=5.6u m=1
X25 NT PB VDD VDD pfet_03v3 L=4u W=2u nf=1 ad=1.6p as=1.6p pd=5.6u ps=5.6u m=1
X26 PG PB VDD VDD pfet_03v3 L=4u W=2u nf=1 ad=1.6p as=1.6p pd=5.6u ps=5.6u m=1
X27 NA PG VDD VDD pfet_03v3 L=4u W=8u nf=1 ad=6.4p as=6.4p pd=17.6u ps=17.6u m=1
X28 NBTOP PG VDD VDD pfet_03v3 L=4u W=8u nf=1 ad=6.4p as=6.4p pd=17.6u ps=17.6u m=1
X29 VREF PG VDD VDD pfet_03v3 L=4u W=8u nf=1 ad=6.4p as=6.4p pd=17.6u ps=17.6u m=1
X30 NOKO NA TOK VDD pfet_03v3 L=4u W=8u nf=1 ad=6.4p as=6.4p pd=17.6u ps=17.6u m=1
X31 NOKL NBTOP TOK VDD pfet_03v3 L=4u W=8u nf=1 ad=6.4p as=6.4p pd=17.6u ps=17.6u m=1
X32 N1 NA NT VDD pfet_03v3 L=4u W=16u nf=1 ad=12.8p as=12.8p pd=33.6u ps=33.6u m=1
X33 N2 NB NT VDD pfet_03v3 L=4u W=16u nf=1 ad=12.8p as=12.8p pd=33.6u ps=33.6u m=1
X34 IBIAS PB VDD VDD pfet_03v3 L=4u W=40u nf=1 ad=32p as=32p pd=81.6u ps=81.6u m=1
X35 VSS VSS EC pnp_10p00x10p00
X36 VSS VSS EC pnp_10p00x10p00
X37 VSS VSS EC pnp_10p00x10p00
X38 VSS VSS EC pnp_10p00x10p00
X39 VSS VSS NA pnp_10p00x10p00
X40 VSS VSS EC pnp_10p00x10p00
X41 VSS VSS ER pnp_10p00x10p00
X42 VSS VSS EC pnp_10p00x10p00
X43 VSS VSS EC pnp_10p00x10p00
X44 VSS VSS EC pnp_10p00x10p00
X45 NOKX VDD cap_mim_2f0_m3m4_noshield c_width=6u c_length=6u
X46 NZ PG cap_mim_2f0_m3m4_noshield c_width=20u c_length=20u
X47 VREF XR2__1 VSS ppolyf_u_3k r_width=2u r_length=256.5u
X48 XR2__2 XR2__1 VSS ppolyf_u_3k r_width=2u r_length=256.5u
X49 XR2__2 XR2__3 VSS ppolyf_u_3k r_width=2u r_length=256.5u
X50 XR2__4 XR2__3 VSS ppolyf_u_3k r_width=2u r_length=256.5u
X51 XR2__4 XR2__5 VSS ppolyf_u_3k r_width=2u r_length=256.5u
X52 XR2__6 XR2__5 VSS ppolyf_u_3k r_width=2u r_length=256.5u
X53 XR2__6 XR2__7 VSS ppolyf_u_3k r_width=2u r_length=256.5u
X54 XR2__8 XR2__7 VSS ppolyf_u_3k r_width=2u r_length=256.5u
X55 XR2__8 XR2__9 VSS ppolyf_u_3k r_width=2u r_length=256.5u
X56 XR2__10 XR2__9 VSS ppolyf_u_3k r_width=2u r_length=256.5u
X57 XR2__10 XR2__11 VSS ppolyf_u_3k r_width=2u r_length=256.5u
X58 XR2__12 XR2__11 VSS ppolyf_u_3k r_width=2u r_length=256.5u
X59 XR2__12 XR2__13 VSS ppolyf_u_3k r_width=2u r_length=256.5u
X60 XR2__14 XR2__13 VSS ppolyf_u_3k r_width=2u r_length=256.5u
X61 XR2__14 XR2__15 VSS ppolyf_u_3k r_width=2u r_length=256.5u
X62 ER XR2__15 VSS ppolyf_u_3k r_width=2u r_length=256.5u
X63 NZ XRZ__1 VSS ppolyf_u_3k r_width=2u r_length=254u
X64 XRZ__2 XRZ__1 VSS ppolyf_u_3k r_width=2u r_length=254u
X65 XRZ__2 XRZ__3 VSS ppolyf_u_3k r_width=2u r_length=254u
X66 N2 XRZ__3 VSS ppolyf_u_3k r_width=2u r_length=254u
X67 NB XR1__1 VSS ppolyf_u_3k r_width=2u r_length=175u
X68 EC XR1__1 VSS ppolyf_u_3k r_width=2u r_length=175u
X69 NBTOP XRT__1 VSS ppolyf_u_3k r_width=2u r_length=8.75u
X70 NB XRT__1 VSS ppolyf_u_3k r_width=2u r_length=8.75u

R_10 N1 N1__par 4967.8583
C_10 N1__par VSS 5.978126e-14
R_11 N2 N2__par 7855.0506
C_11 N2__par VSS 8.4779094e-14
R_12 NKM NKM__par 4876.8874
C_12 NKM__par VSS 5.7923066e-14
R_13 TOK TOK__par 4690.5254
C_13 TOK__par VSS 5.2350545e-14
R_14 NOKO NOKO__par 4792.4183
C_14 NOKO__par VSS 5.9161863e-14
R_15 NOKL NOKL__par 4883.997
C_15 NOKL__par VSS 6.0794305e-14
R_16 NOKX NOKX__par 4848.4085
C_16 NOKX__par VSS 5.9751918e-14
R_17 KS1 KS1__par 4818.8511
C_17 KS1__par VSS 5.4330567e-14
R_18 KS2 KS2__par 4819.3911
C_18 KS2__par VSS 5.4548635e-14
R_19 KS3 KS3__par 4819.931
C_19 KS3__par VSS 5.4766704e-14
R_20 KS4 KS4__par 4820.471
C_20 KS4__par VSS 5.4984773e-14
R_21 NKG NKG__par 4848.0503
C_21 NKG__par VSS 5.7785044e-14
R_23 NB NB__par 7667.0394
C_23 NB__par VSS 7.6118691e-14
R_24 EC EC__par 2791.7858
C_24 EC__par VSS 7.4268842e-14
R_25 NZ NZ__par 2787.2554
C_25 NZ__par VSS 2.545538e-14
R_27 XRZ__2 XRZ__2__par 18.25
C_27 XRZ__2__par VSS 1.8067e-15
R_28 XR2__14 XR2__14__par 18.25
C_28 XR2__14__par VSS 1.8067e-15
R_29 XR2__12 XR2__12__par 18.25
C_29 XR2__12__par VSS 1.8067e-15
R_3 PG PG__par 5084.0134
C_3 PG__par VSS 6.8147207e-14
R_30 XR2__10 XR2__10__par 18.25
C_30 XR2__10__par VSS 1.8067e-15
R_31 XR2__8 XR2__8__par 18.25
C_31 XR2__8__par VSS 1.8067e-15
R_32 XR2__6 XR2__6__par 18.25
C_32 XR2__6__par VSS 1.8067e-15
R_33 XR2__4 XR2__4__par 18.25
C_33 XR2__4__par VSS 1.8067e-15
R_34 XR2__2 XR2__2__par 18.25
C_34 XR2__2__par VSS 1.8067e-15
R_35 NA NA__par 8008.5898
C_35 NA__par VSS 8.7590412e-14
R_36 ER ER__par 2787.674
C_36 ER__par VSS 3.3170077e-14
R_37 XRT__1 XRT__1__par 18.25
C_37 XRT__1__par VSS 1.8067e-15
R_4 NBTOP NBTOP__par 7796.7657
C_4 NBTOP__par VSS 7.8325844e-14
R_43 XR1__1 XR1__1__par 18.25
C_43 XR1__1__par VSS 1.8067e-15
R_44 XRZ__3 XRZ__3__par 18.25
C_44 XRZ__3__par VSS 1.8067e-15
R_45 XRZ__1 XRZ__1__par 18.25
C_45 XRZ__1__par VSS 1.8067e-15
R_46 XR2__13 XR2__13__par 18.25
C_46 XR2__13__par VSS 1.8067e-15
R_47 XR2__11 XR2__11__par 18.25
C_47 XR2__11__par VSS 1.8067e-15
R_48 XR2__1 XR2__1__par 18.25
C_48 XR2__1__par VSS 1.8067e-15
R_49 XR2__3 XR2__3__par 18.25
C_49 XR2__3__par VSS 1.8067e-15
R_50 XR2__5 XR2__5__par 18.25
C_50 XR2__5__par VSS 1.8067e-15
R_51 XR2__7 XR2__7__par 18.25
C_51 XR2__7__par VSS 1.8067e-15
R_52 XR2__9 XR2__9__par 18.25
C_52 XR2__9__par VSS 1.8067e-15
R_53 XR2__15 XR2__15__par 18.25
C_53 XR2__15__par VSS 1.8067e-15
R_6 NBG NBG__par 4871.7578
C_6 NBG__par VSS 5.5851412e-14
R_7 PB PB__par 5396.0003
C_7 PB__par VSS 7.9168117e-14
R_9 NT NT__par 4684.5858
C_9 NT__par VSS 4.9951788e-14
RBIAS_OK BIAS_OK BIAS_OK__par 4679.0384
CBIAS_OK BIAS_OK__par VSS 4.7753184e-14
RIBIAS IBIAS IBIAS__par 4663.4113
CIBIAS IBIAS__par VSS 4.1483963e-14
RVDD VDD VDD__par 371.4414
CVDD VDD__par VSS 1.29011679e-13
RVREF VREF VREF__par 7695.5815
CVREF VREF__par VSS 7.3513489e-14
RVSS VSS VSS__par 145.0301
CVSS VSS__par VSS 2.53093198e-13
.ends bias_core
