* bias_core -- klt lvs reference netlist
* generated by layout/lvs_reference.py from design/netlist/bias_core.spice
* Do not edit: edit the schematic, re-run design/netlist.py, re-run this.
.SUBCKT bias_core BIAS_OK IBIAS VDD VREF VSS
M1 NBG NBG VSS VSS nfet L=4U W=2U
M2 NA PG VDD VDD pfet L=4U W=8U
M3 NBTOP PG VDD VDD pfet L=4U W=8U
M4 VREF PG VDD VDD pfet L=4U W=8U
M5 NBG PG VDD VDD pfet L=4U W=2U
M6 PB PB VDD VDD pfet L=4U W=2U
M7 IBIAS PB VDD VDD pfet L=4U W=40U
M8 NT PB VDD VDD pfet L=4U W=2U
M9 N1 NA NT VDD pfet L=4U W=16U
M10 N2 NB NT VDD pfet L=4U W=16U
M11 PG PB VDD VDD pfet L=4U W=2U
M12 NKM PB VDD VDD pfet L=4U W=1U
M13 TOK PB VDD VDD pfet L=4U W=1U
M14 NOKO NA TOK VDD pfet L=4U W=8U
M15 NOKL NBTOP TOK VDD pfet L=4U W=8U
M16 NOKX PB VDD VDD pfet L=4U W=1U
M17 BIAS_OK NOKX VDD VDD pfet L=4U W=1U
M18 PB NBG VSS VSS nfet L=4U W=2U
M19 N1 N1 VSS VSS nfet L=8U W=4U
M20 N2 N1 VSS VSS nfet L=8U W=4U
M21 PG N2 VSS VSS nfet L=8U W=8U
M22 VDD VDD KS1 VSS nfet L=8U W=1U
M23 KS1 KS1 KS2 VSS nfet L=8U W=1U
M24 KS2 KS2 KS3 VSS nfet L=8U W=1U
M25 KS3 KS3 KS4 VSS nfet L=8U W=1U
M26 KS4 KS4 NKG VSS nfet L=8U W=1U
M27 NKM NKM VSS VSS nfet L=4U W=2U
M28 NKG NKM VSS VSS nfet L=4U W=8U
M29 PG NKG VSS VSS nfet L=4U W=1U
M30 NOKL NOKL VSS VSS nfet L=4U W=2U
M31 NOKO NOKL VSS VSS nfet L=4U W=2U
M32 NOKO NKG VSS VSS nfet L=1U W=2U
M33 NOKX NOKO VSS VSS nfet L=4U W=2U
M34 BIAS_OK NOKX VSS VSS nfet L=0.5U W=4U
R35 NBTOP XRT.1 VSS 4375 ppolyf_u_1k
R36 XRT.1 NB VSS 4375 ppolyf_u_1k
R37 NB XR1.1 VSS 87500 ppolyf_u_1k
R38 XR1.1 EC VSS 87500 ppolyf_u_1k
R39 VREF XR2.1 VSS 128250 ppolyf_u_1k
R40 XR2.1 XR2.2 VSS 128250 ppolyf_u_1k
R41 XR2.2 XR2.3 VSS 128250 ppolyf_u_1k
R42 XR2.3 XR2.4 VSS 128250 ppolyf_u_1k
R43 XR2.4 XR2.5 VSS 128250 ppolyf_u_1k
R44 XR2.5 XR2.6 VSS 128250 ppolyf_u_1k
R45 XR2.6 XR2.7 VSS 128250 ppolyf_u_1k
R46 XR2.7 XR2.8 VSS 128250 ppolyf_u_1k
R47 XR2.8 XR2.9 VSS 128250 ppolyf_u_1k
R48 XR2.9 XR2.10 VSS 128250 ppolyf_u_1k
R49 XR2.10 XR2.11 VSS 128250 ppolyf_u_1k
R50 XR2.11 XR2.12 VSS 128250 ppolyf_u_1k
R51 XR2.12 XR2.13 VSS 128250 ppolyf_u_1k
R52 XR2.13 XR2.14 VSS 128250 ppolyf_u_1k
R53 XR2.14 XR2.15 VSS 128250 ppolyf_u_1k
R54 XR2.15 ER VSS 128250 ppolyf_u_1k
R55 NZ XRZ.1 VSS 127000 ppolyf_u_1k
R56 XRZ.1 XRZ.2 VSS 127000 ppolyf_u_1k
R57 XRZ.2 XRZ.3 VSS 127000 ppolyf_u_1k
R58 XRZ.3 N2 VSS 127000 ppolyf_u_1k
Q59 VSS VSS NA bjt AE=100P
Q60 VSS VSS EC bjt AE=100P
Q61 VSS VSS EC bjt AE=100P
Q62 VSS VSS EC bjt AE=100P
Q63 VSS VSS EC bjt AE=100P
Q64 VSS VSS EC bjt AE=100P
Q65 VSS VSS EC bjt AE=100P
Q66 VSS VSS EC bjt AE=100P
Q67 VSS VSS EC bjt AE=100P
Q68 VSS VSS ER bjt AE=100P
C69 PG NZ 8.15064e-13 cap_mim_2f0_m4m5_noshield A=400P P=80U
C70 VDD NOKX 7.73592e-14 cap_mim_2f0_m4m5_noshield A=36P P=24U
.ENDS bias_core
