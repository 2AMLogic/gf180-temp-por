* temp_por_top -- COMPOSITE post-layout netlist
* generated by layout/composite_netlist.py -- do not edit.
*
* WHAT THIS IS
*   MOS devices and interconnect parasitics taken from the LAYOUT
*     layout/reports/temp_por_top/extracted-parasitics.spice
*     (klt extract --deck gf180mcu --parasitics), plus every non-MOS
*     device taken VERBATIM from the golden schematic export
*     design/netlist/temp_por_top.spice.
*
* WHAT THIS IS NOT
*   It is NOT a parasitic-extracted analog core. The vertical PNPs,
*   poly resistors and MiM caps below are IDEAL SCHEMATIC DEVICES:
*   they are not drawn in the layout at all, so they carry no
*   extracted geometry, no parasitic R/C, and no layout-derived
*   matching. Any claim recorded against this netlist must say so in
*   the record's Claim field -- what it substantiates is real
*   interconnect parasitics loading the real MOS topology, and
*   nothing more. See layout/composite/AUDIT.md.
*
*   Device bodies are the other place this netlist takes connectivity
*   from the schematic: the curated deck draws no tap or well-label
*   layer, so an extracted body lands on a global substrate net or an
*   anonymous well net. Those are restored to the schematic's own
*   body nodes here, because a floating body cannot be simulated.
*
.subckt temp_por_top VDD VSS PTAT CTAT RESETn

* ---- MOS devices: extracted from the layout ----
* device instance $1 r0 *1 112.4,-399 nfet
XM__1 xbias__NBG xbias__NBG VSS VSS nfet_03v3 L=4u W=2u nf=1 ad=1.6p as=1.6p pd=5.6u ps=5.6u m=1
* device instance $2 r0 *1 119,-399 nfet
XM__2 xbias__PB xbias__NBG VSS VSS nfet_03v3 L=4u W=2u nf=1 ad=1.6p as=1.6p pd=5.6u ps=5.6u m=1
* device instance $3 r0 *1 127.6,-398 nfet
XM__3 xbias__N1 xbias__N1 VSS VSS nfet_03v3 L=8u W=4u nf=1 ad=3.2p as=3.2p pd=9.6u ps=9.6u m=1
* device instance $4 r0 *1 138.2,-398 nfet
XM__4 xbias__N2 xbias__N1 VSS VSS nfet_03v3 L=8u W=4u nf=1 ad=3.2p as=3.2p pd=9.6u ps=9.6u m=1
* device instance $5 r0 *1 148.8,-396 nfet
XM__5 xbias__PG xbias__N2 VSS VSS nfet_03v3 L=8u W=8u nf=1 ad=6.4p as=6.4p pd=17.6u ps=17.6u m=1
* device instance $6 r0 *1 159.4,-399.5 nfet
XM__6 VDD VDD xbias__KS1 VSS nfet_03v3 L=8u W=1u nf=1 ad=0.8p as=0.8p pd=3.6u ps=3.6u m=1
* device instance $7 r0 *1 170,-399.5 nfet
XM__7 xbias__KS1 xbias__KS1 xbias__KS2 VSS nfet_03v3 L=8u W=1u nf=1 ad=0.8p as=0.8p pd=3.6u ps=3.6u m=1
* device instance $8 r0 *1 180.6,-399.5 nfet
XM__8 xbias__KS2 xbias__KS2 xbias__KS3 VSS nfet_03v3 L=8u W=1u nf=1 ad=0.8p as=0.8p pd=3.6u ps=3.6u m=1
* device instance $9 r0 *1 191.2,-399.5 nfet
XM__9 xbias__KS3 xbias__KS3 xbias__KS4 VSS nfet_03v3 L=8u W=1u nf=1 ad=0.8p as=0.8p pd=3.6u ps=3.6u m=1
* device instance $10 r0 *1 201.8,-399.5 nfet
XM__10 xbias__KS4 xbias__KS4 xbias__NKG VSS nfet_03v3 L=8u W=1u nf=1 ad=0.8p as=0.8p pd=3.6u ps=3.6u m=1
* device instance $11 r0 *1 210.4,-399 nfet
XM__11 xbias__NKM xbias__NKM VSS VSS nfet_03v3 L=4u W=2u nf=1 ad=1.6p as=1.6p pd=5.6u ps=5.6u m=1
* device instance $12 r0 *1 217,-396 nfet
XM__12 xbias__NKG xbias__NKM VSS VSS nfet_03v3 L=4u W=8u nf=1 ad=6.4p as=6.4p pd=17.6u ps=17.6u m=1
* device instance $13 r0 *1 223.6,-399.5 nfet
XM__13 xbias__PG xbias__NKG VSS VSS nfet_03v3 L=4u W=1u nf=1 ad=0.8p as=0.8p pd=3.6u ps=3.6u m=1
* device instance $14 r0 *1 230.2,-399 nfet
XM__14 xbias__NOKL xbias__NOKL VSS VSS nfet_03v3 L=4u W=2u nf=1 ad=1.6p as=1.6p pd=5.6u ps=5.6u m=1
* device instance $15 r0 *1 236.8,-399 nfet
XM__15 xbias__NOKO xbias__NOKL VSS VSS nfet_03v3 L=4u W=2u nf=1 ad=1.6p as=1.6p pd=5.6u ps=5.6u m=1
* device instance $16 r0 *1 241.9,-399 nfet
XM__16 xbias__NOKO xbias__NKG VSS VSS nfet_03v3 L=1u W=2u nf=1 ad=1.6p as=1.6p pd=5.6u ps=5.6u m=1
* device instance $17 r0 *1 247,-399 nfet
XM__17 xbias__NOKX xbias__NOKO VSS VSS nfet_03v3 L=4u W=2u nf=1 ad=1.6p as=1.6p pd=5.6u ps=5.6u m=1
* device instance $18 r0 *1 251.85,-398 nfet
XM__18 BIAS_OK xbias__NOKX VSS VSS nfet_03v3 L=0.5u W=4u nf=1 ad=3.2p as=3.2p pd=9.6u ps=9.6u m=1
* device instance $19 r0 *1 471.8,-399 nfet
XM__19 xcmp__NA xcmp__SNS xcmp__TN VSS nfet_03v3 L=1u W=2u nf=1 ad=1.6p as=1.6p pd=5.6u ps=5.6u m=1
* device instance $20 r0 *1 475.4,-399 nfet
XM__20 xcmp__CMPO VREF xcmp__TN VSS nfet_03v3 L=1u W=2u nf=1 ad=1.6p as=1.6p pd=5.6u ps=5.6u m=1
* device instance $21 r0 *1 483.5,-399.5 nfet
XM__21 xcmp__TN xcmp__NBG VSS VSS nfet_03v3 L=10u W=1u nf=1 ad=0.8p as=0.8p pd=3.6u ps=3.6u m=1
* device instance $22 r0 *1 492.1,-399 nfet
XM__22 IBIAS xcmp__NBG VSS VSS nfet_03v3 L=2u W=2u nf=1 ad=1.6p as=1.6p pd=5.6u ps=5.6u m=1
* device instance $23 r0 *1 495.95,-399 nfet
XM__23 IBIAS BIAS_OK xcmp__NBG VSS nfet_03v3 L=0.5u W=2u nf=1 ad=1.6p as=1.6p pd=5.6u ps=5.6u m=1
* device instance $24 r0 *1 499.05,-399 nfet
XM__24 xcmp__NBG xcmp__BIAS_OKB VSS VSS nfet_03v3 L=0.5u W=2u nf=1 ad=1.6p as=1.6p pd=5.6u ps=5.6u m=1
* device instance $25 r0 *1 502.4,-399.5 nfet
XM__25 IBIAS xcmp__BIAS_OKB VSS VSS nfet_03v3 L=1u W=1u nf=1 ad=0.8p as=0.8p pd=3.6u ps=3.6u m=1
* device instance $26 r0 *1 505.75,-395 nfet
XM__26 xcmp__SNSB xcmp__N1 VSS VSS nfet_03v3 L=0.5u W=10u nf=1 ad=8p as=8p pd=21.6u ps=21.6u m=1
* device instance $27 r0 *1 509.1,-399 nfet
XM__27 xcmp__CMPO xcmp__BIAS_OKB VSS VSS nfet_03v3 L=1u W=2u nf=1 ad=1.6p as=1.6p pd=5.6u ps=5.6u m=1
* device instance $28 r0 *1 512.45,-399.5 nfet
XM__28 xcmp__N1 xcmp__CMPO VSS VSS nfet_03v3 L=0.5u W=1u nf=1 ad=0.8p as=0.8p pd=3.6u ps=3.6u m=1
* device instance $29 r0 *1 515.55,-399.5 nfet
XM__29 POR_RAW xcmp__N1 VSS VSS nfet_03v3 L=0.5u W=1u nf=1 ad=0.8p as=0.8p pd=3.6u ps=3.6u m=1
* device instance $30 r0 *1 523.35,-399.5 nfet
XM__30 xcmp__BIAS_OKB BIAS_OK VSS VSS nfet_03v3 L=0.5u W=1u nf=1 ad=0.8p as=0.5p pd=3.6u ps=3u m=1
* device instance $31 r0 *1 822.8,-398 nfet
XM__31 IBIAS IBIAS VSS VSS nfet_03v3 L=4u W=4u nf=1 ad=3.2p as=3.2p pd=9.6u ps=9.6u m=1
* device instance $32 r0 *1 839.9,-399.75 nfet
XM__32 xpor__PDN IBIAS VSS VSS nfet_03v3 L=25u W=0.5u nf=1 ad=0.4p as=0.4p pd=2.6u ps=2.6u m=1
* device instance $33 r0 *1 860,-399 nfet
XM__33 xpor__NDL xpor__NDL VSS VSS nfet_03v3 L=10u W=2u nf=1 ad=1.6p as=1.6p pd=5.6u ps=5.6u m=1
* device instance $34 r0 *1 872.6,-395 nfet
XM__34 xpor__NDGN xpor__NDL VSS VSS nfet_03v3 L=10u W=10u nf=1 ad=8p as=8p pd=21.6u ps=21.6u m=1
* device instance $35 r0 *1 880.45,-399.5 nfet
XM__35 xpor__NDG POR_RAW xpor__NDGN VSS nfet_03v3 L=0.5u W=1u nf=1 ad=0.8p as=0.8p pd=3.6u ps=3.6u m=1
* device instance $36 r0 *1 883.55,-399 nfet
XM__36 xpor__PGDG xpor__NDG VSS VSS nfet_03v3 L=0.5u W=2u nf=1 ad=1.6p as=1.6p pd=5.6u ps=5.6u m=1
* device instance $37 r0 *1 887.4,-399.75 nfet
XM__37 xpor__PGDGB xpor__PGDG VSS VSS nfet_03v3 L=2u W=0.5u nf=1 ad=0.4p as=0.4p pd=2.6u ps=2.6u m=1
* device instance $38 r0 *1 891.5,-399.5 nfet
XM__38 xpor__TIM xpor__PGDGB VSS VSS nfet_03v3 L=1u W=1u nf=1 ad=0.8p as=0.8p pd=3.6u ps=3.6u m=1
* device instance $39 r0 *1 899.6,-399.75 nfet
XM__39 xpor__ND1 xpor__NDL VSS VSS nfet_03v3 L=10u W=0.5u nf=1 ad=0.4p as=0.4p pd=2.6u ps=2.6u m=1
* device instance $40 r0 *1 907.7,-399.5 nfet
XM__40 xpor__TRIP xpor__ND1 VSS VSS nfet_03v3 L=1u W=1u nf=1 ad=0.8p as=0.8p pd=3.6u ps=3.6u m=1
* device instance $41 r0 *1 911.05,-399 nfet
XM__41 xpor__RSTB xpor__TRIP xpor__NNAND VSS nfet_03v3 L=0.5u W=2u nf=1 ad=1.6p as=1.6p pd=5.6u ps=5.6u m=1
* device instance $42 r0 *1 914.15,-399 nfet
XM__42 xpor__NNAND xpor__PGDG VSS VSS nfet_03v3 L=0.5u W=2u nf=1 ad=1.6p as=1.6p pd=5.6u ps=5.6u m=1
* device instance $43 r0 *1 1028.65,-395 nfet
XM__43 RESETn xpor__RSTB VSS VSS nfet_03v3 L=0.5u W=10u nf=1 ad=8p as=8p pd=21.6u ps=21.6u m=1
* device instance $44 r0 *1 49.5,-2 nfet
XM__44 VSS VSS VSS VSS nfet_03v3 L=8u W=4u nf=1 ad=3.2p as=3.2p pd=9.6u ps=9.6u m=1
* device instance $45 r0 *1 59.6,-2 nfet
XM__45 xtemp__N1 xtemp__N1 VSS VSS nfet_03v3 L=8u W=4u nf=1 ad=3.2p as=3.2p pd=9.6u ps=9.6u m=1
* device instance $46 r0 *1 69.7,-2 nfet
XM__46 xtemp__N2 xtemp__N1 VSS VSS nfet_03v3 L=8u W=4u nf=1 ad=3.2p as=3.2p pd=9.6u ps=9.6u m=1
* device instance $47 r0 *1 79.8,-2 nfet
XM__47 xtemp__N2 xtemp__N1 VSS VSS nfet_03v3 L=8u W=4u nf=1 ad=3.2p as=3.2p pd=9.6u ps=9.6u m=1
* device instance $48 r0 *1 89.9,-2 nfet
XM__48 xtemp__N1 xtemp__N1 VSS VSS nfet_03v3 L=8u W=4u nf=1 ad=3.2p as=3.2p pd=9.6u ps=9.6u m=1
* device instance $49 r0 *1 100,-2 nfet
XM__49 VSS VSS VSS VSS nfet_03v3 L=8u W=4u nf=1 ad=3.2p as=3.2p pd=9.6u ps=9.6u m=1
* device instance $50 r0 *1 177.5,-4 nfet
XM__50 xtemp__PG xtemp__N2 VSS VSS nfet_03v3 L=8u W=8u nf=1 ad=6.4p as=6.4p pd=17.6u ps=17.6u m=1
* device instance $51 r0 *1 190.7,-2 nfet
XM__51 IBIAS xtemp__NBG VSS VSS nfet_03v3 L=2u W=4u nf=1 ad=3.2p as=3.2p pd=9.6u ps=9.6u m=1
* device instance $52 r0 *1 194.05,-1 nfet
XM__52 IBIAS RESETn xtemp__NBG VSS nfet_03v3 L=0.5u W=2u nf=1 ad=1.6p as=1.6p pd=5.6u ps=5.6u m=1
* device instance $53 r0 *1 196.65,-1 nfet
XM__53 xtemp__NBG xtemp__ENB VSS VSS nfet_03v3 L=0.5u W=2u nf=1 ad=1.6p as=1.6p pd=5.6u ps=5.6u m=1
* device instance $54 r0 *1 200,-2 nfet
XM__54 xtemp__PB xtemp__NBG VSS VSS nfet_03v3 L=2u W=4u nf=1 ad=3.2p as=3.2p pd=9.6u ps=9.6u m=1
* device instance $55 r0 *1 210.2,-2 nfet
XM__55 xtemp__PCAS xtemp__NBG VSS VSS nfet_03v3 L=2u W=4u nf=1 ad=3.2p as=3.2p pd=9.6u ps=9.6u m=1
* device instance $56 r0 *1 226.25,-0.5 nfet
XM__56 xtemp__ENB RESETn VSS VSS nfet_03v3 L=0.5u W=1u nf=1 ad=0.8p as=0.8p pd=3.6u ps=3.6u m=1
* device instance $57 r0 *1 239.7,-1 nfet
XM__57 xtemp__ND xtemp__NR VSS VSS nfet_03v3 L=2u W=2u nf=1 ad=1.6p as=1.6p pd=5.6u ps=5.6u m=1
* device instance $58 r0 *1 243.3,-2 nfet
XM__58 xtemp__PG xtemp__ND VSS VSS nfet_03v3 L=1u W=4u nf=1 ad=3.2p as=3.2p pd=9.6u ps=9.6u m=1
* device instance $59 r0 *1 253,-1 nfet
XM__59 xtemp__NR xtemp__NR VSS VSS nfet_03v3 L=2u W=2u nf=1 ad=1.6p as=1.6p pd=5.6u ps=5.6u m=1
* device instance $60 r0 *1 256.35,-1 nfet
XM__60 xtemp__ND xtemp__ENB VSS VSS nfet_03v3 L=0.5u W=2u nf=1 ad=1.6p as=1.6p pd=5.6u ps=5.6u m=1
* device instance $61 r0 *1 261.8,-0.5 nfet
XM__61 PTAT xtemp__ENB VSS VSS nfet_03v3 L=1u W=1u nf=1 ad=0.8p as=0.8p pd=3.6u ps=3.6u m=1
* device instance $62 r0 *1 264.9,-0.5 nfet
XM__62 CTAT xtemp__ENB VSS VSS nfet_03v3 L=1u W=1u nf=1 ad=0.8p as=0.8p pd=3.6u ps=3.6u m=1
* device instance $63 r0 *1 268,-1 nfet
XM__63 xtemp__N2 xtemp__ENB VSS VSS nfet_03v3 L=1u W=2u nf=1 ad=1.6p as=1.6p pd=5.6u ps=5.6u m=1
* device instance $64 r0 *1 271.1,-1 nfet
XM__64 xtemp__NT xtemp__ENB VSS VSS nfet_03v3 L=1u W=2u nf=1 ad=1.6p as=1.6p pd=5.6u ps=5.6u m=1
* device instance $65 r0 *1 273.95,-16 nfet
XM__65 xtemp__T5 VDD xtemp__T4 VSS nfet_03v3 L=0.5u W=32u nf=1 ad=25.6p as=25.6p pd=65.6u ps=65.6u m=1
* device instance $66 r0 *1 276.55,-16 nfet
XM__66 xtemp__T3 VSS xtemp__T2 VSS nfet_03v3 L=0.5u W=32u nf=1 ad=25.6p as=25.6p pd=65.6u ps=65.6u m=1
* device instance $67 r0 *1 279.15,-16 nfet
XM__67 xtemp__T1 VSS xtemp__T0 VSS nfet_03v3 L=0.5u W=32u nf=1 ad=25.6p as=25.6p pd=65.6u ps=65.6u m=1
* device instance $68 r0 *1 281.75,-16 nfet
XM__68 xtemp__T0 VSS VSS VSS nfet_03v3 L=0.5u W=32u nf=1 ad=25.6p as=25.6p pd=65.6u ps=65.6u m=1
* device instance $69 r0 *1 284.35,-16 nfet
XM__69 xtemp__T2 VSS xtemp__T1 VSS nfet_03v3 L=0.5u W=32u nf=1 ad=25.6p as=25.6p pd=65.6u ps=65.6u m=1
* device instance $70 r0 *1 286.95,-16 nfet
XM__70 xtemp__T4 VSS xtemp__T3 VSS nfet_03v3 L=0.5u W=32u nf=1 ad=25.6p as=25.6p pd=65.6u ps=65.6u m=1
* device instance $71 r0 *1 2.8,-396 pfet
XM__71 xbias__NA xbias__PG VDD VDD pfet_03v3 L=4u W=8u nf=1 ad=6.4p as=6.4p pd=17.6u ps=17.6u m=1
* device instance $72 r0 *1 9.4,-396 pfet
XM__72 xbias__NBTOP xbias__PG VDD VDD pfet_03v3 L=4u W=8u nf=1 ad=6.4p as=6.4p pd=17.6u ps=17.6u m=1
* device instance $73 r0 *1 16,-396 pfet
XM__73 VREF xbias__PG VDD VDD pfet_03v3 L=4u W=8u nf=1 ad=6.4p as=6.4p pd=17.6u ps=17.6u m=1
* device instance $74 r0 *1 22.6,-399 pfet
XM__74 xbias__NBG xbias__PG VDD VDD pfet_03v3 L=4u W=2u nf=1 ad=1.6p as=1.6p pd=5.6u ps=5.6u m=1
* device instance $75 r0 *1 29.2,-399 pfet
XM__75 xbias__PB xbias__PB VDD VDD pfet_03v3 L=4u W=2u nf=1 ad=1.6p as=1.6p pd=5.6u ps=5.6u m=1
* device instance $76 r0 *1 35.8,-380 pfet
XM__76 IBIAS xbias__PB VDD VDD pfet_03v3 L=4u W=40u nf=1 ad=32p as=32p pd=81.6u ps=81.6u m=1
* device instance $77 r0 *1 42.4,-399 pfet
XM__77 xbias__NT xbias__PB VDD VDD pfet_03v3 L=4u W=2u nf=1 ad=1.6p as=1.6p pd=5.6u ps=5.6u m=1
* device instance $78 r0 *1 49,-392 pfet
XM__78 xbias__N1 xbias__NA xbias__NT VDD pfet_03v3 L=4u W=16u nf=1 ad=12.8p as=12.8p pd=33.6u ps=33.6u m=1
* device instance $79 r0 *1 55.6,-392 pfet
XM__79 xbias__N2 xbias__NB xbias__NT VDD pfet_03v3 L=4u W=16u nf=1 ad=12.8p as=12.8p pd=33.6u ps=33.6u m=1
* device instance $80 r0 *1 62.2,-399 pfet
XM__80 xbias__PG xbias__PB VDD VDD pfet_03v3 L=4u W=2u nf=1 ad=1.6p as=1.6p pd=5.6u ps=5.6u m=1
* device instance $81 r0 *1 68.8,-399.5 pfet
XM__81 xbias__NKM xbias__PB VDD VDD pfet_03v3 L=4u W=1u nf=1 ad=0.8p as=0.8p pd=3.6u ps=3.6u m=1
* device instance $82 r0 *1 75.4,-399.5 pfet
XM__82 xbias__TOK xbias__PB VDD VDD pfet_03v3 L=4u W=1u nf=1 ad=0.8p as=0.8p pd=3.6u ps=3.6u m=1
* device instance $83 r0 *1 82,-396 pfet
XM__83 xbias__NOKO xbias__NA xbias__TOK VDD pfet_03v3 L=4u W=8u nf=1 ad=6.4p as=6.4p pd=17.6u ps=17.6u m=1
* device instance $84 r0 *1 88.6,-396 pfet
XM__84 xbias__NOKL xbias__NBTOP xbias__TOK VDD pfet_03v3 L=4u W=8u nf=1 ad=6.4p as=6.4p pd=17.6u ps=17.6u m=1
* device instance $85 r0 *1 95.2,-399.5 pfet
XM__85 xbias__NOKX xbias__PB VDD VDD pfet_03v3 L=4u W=1u nf=1 ad=0.8p as=0.8p pd=3.6u ps=3.6u m=1
* device instance $86 r0 *1 101.8,-399.5 pfet
XM__86 BIAS_OK xbias__NOKX VDD VDD pfet_03v3 L=4u W=1u nf=1 ad=0.8p as=0.8p pd=3.6u ps=3.6u m=1
* device instance $87 r0 *1 451.3,-398 pfet
XM__87 xcmp__NA xcmp__NA xcmp__VDDA VDD pfet_03v3 L=1u W=4u nf=1 ad=3.2p as=3.2p pd=9.6u ps=9.6u m=1
* device instance $88 r0 *1 454.9,-398 pfet
XM__88 xcmp__CMPO xcmp__NA xcmp__VDDA VDD pfet_03v3 L=1u W=4u nf=1 ad=3.2p as=3.2p pd=9.6u ps=9.6u m=1
* device instance $89 r0 *1 458.25,-398 pfet
XM__89 xcmp__VDDA xcmp__BIAS_OKB VDD VDD pfet_03v3 L=0.5u W=4u nf=1 ad=3.2p as=3.2p pd=9.6u ps=9.6u m=1
* device instance $90 r0 *1 461.35,-399 pfet
XM__90 xcmp__N1 xcmp__CMPO VDD VDD pfet_03v3 L=0.5u W=2u nf=1 ad=1.6p as=1.6p pd=5.6u ps=5.6u m=1
* device instance $91 r0 *1 464.45,-399 pfet
XM__91 POR_RAW xcmp__N1 VDD VDD pfet_03v3 L=0.5u W=2u nf=1 ad=1.6p as=1.6p pd=5.6u ps=5.6u m=1
* device instance $92 r0 *1 926,-399 pfet
XM__92 xpor__PDN xpor__PDN VDD VDD pfet_03v3 L=10u W=2u nf=1 ad=1.6p as=1.6p pd=5.6u ps=5.6u m=1
* device instance $93 r0 *1 938.6,-399 pfet
XM__93 xpor__NDL xpor__PDN VDD VDD pfet_03v3 L=10u W=2u nf=1 ad=1.6p as=1.6p pd=5.6u ps=5.6u m=1
* device instance $94 r0 *1 951.2,-395 pfet
XM__94 xpor__NDGP xpor__PDN VDD VDD pfet_03v3 L=10u W=10u nf=1 ad=8p as=8p pd=21.6u ps=21.6u m=1
* device instance $95 r0 *1 963.8,-399.75 pfet
XM__95 xpor__NTS xpor__PDN VDD VDD pfet_03v3 L=10u W=0.5u nf=1 ad=0.4p as=0.4p pd=2.6u ps=2.6u m=1
* device instance $96 r0 *1 976.4,-399.75 pfet
XM__96 xpor__TRIP xpor__PDN VDD VDD pfet_03v3 L=10u W=0.5u nf=1 ad=0.4p as=0.4p pd=2.6u ps=2.6u m=1
* device instance $97 r0 *1 984.25,-399.5 pfet
XM__97 xpor__NDG POR_RAW xpor__NDGP VDD pfet_03v3 L=0.5u W=1u nf=1 ad=0.8p as=0.8p pd=3.6u ps=3.6u m=1
* device instance $98 r0 *1 988.1,-399.75 pfet
XM__98 xpor__PGDG xpor__NDG VDD VDD pfet_03v3 L=2u W=0.5u nf=1 ad=0.4p as=0.4p pd=2.6u ps=2.6u m=1
* device instance $99 r0 *1 991.95,-399 pfet
XM__99 xpor__PGDGB xpor__PGDG VDD VDD pfet_03v3 L=0.5u W=2u nf=1 ad=1.6p as=1.6p pd=5.6u ps=5.6u m=1
* device instance $100 r0 *1 995.3,-399 pfet
XM__100 xpor__TIM xpor__PGDGB xpor__NTS VDD pfet_03v3 L=1u W=2u nf=1 ad=1.6p as=1.6p pd=5.6u ps=5.6u m=1
* device instance $101 r0 *1 998.9,-399 pfet
XM__101 xpor__ND1 xpor__TIM VDD VDD pfet_03v3 L=1u W=2u nf=1 ad=1.6p as=1.6p pd=5.6u ps=5.6u m=1
* device instance $102 r0 *1 1002.25,-398 pfet
XM__102 xpor__RSTB xpor__TRIP VDD VDD pfet_03v3 L=0.5u W=4u nf=1 ad=3.2p as=3.2p pd=9.6u ps=9.6u m=1
* device instance $103 r0 *1 1005.35,-398 pfet
XM__103 xpor__RSTB xpor__PGDG VDD VDD pfet_03v3 L=0.5u W=4u nf=1 ad=3.2p as=3.2p pd=9.6u ps=9.6u m=1
* device instance $104 r0 *1 1013.2,-399.75 pfet
XM__104 xpor__RSTB RESETn VDD VDD pfet_03v3 L=10u W=0.5u nf=1 ad=0.4p as=0.4p pd=2.6u ps=2.6u m=1
* device instance $105 r0 *1 1021.3,-399.5 pfet
XM__105 RESETn xpor__RSTB VDD VDD pfet_03v3 L=1u W=1u nf=1 ad=0.8p as=0.8p pd=3.6u ps=3.6u m=1
* device instance $106 r0 *1 2.8,40 pfet
XM__106 xtemp__NT xtemp__NT xtemp__NT xtemp__NT pfet_03v3 L=4u W=16u nf=1 ad=12.8p as=12.8p pd=33.6u ps=33.6u m=1
* device instance $107 r0 *1 8.9,40 pfet
XM__107 xtemp__N1 xtemp__NA xtemp__NT xtemp__NT pfet_03v3 L=4u W=16u nf=1 ad=12.8p as=12.8p pd=33.6u ps=33.6u m=1
* device instance $108 r0 *1 15,40 pfet
XM__108 xtemp__N2 xtemp__NB xtemp__NT xtemp__NT pfet_03v3 L=4u W=16u nf=1 ad=12.8p as=12.8p pd=33.6u ps=33.6u m=1
* device instance $109 r0 *1 21.1,40 pfet
XM__109 xtemp__N2 xtemp__NB xtemp__NT xtemp__NT pfet_03v3 L=4u W=16u nf=1 ad=12.8p as=12.8p pd=33.6u ps=33.6u m=1
* device instance $110 r0 *1 27.2,40 pfet
XM__110 xtemp__N1 xtemp__NA xtemp__NT xtemp__NT pfet_03v3 L=4u W=16u nf=1 ad=12.8p as=12.8p pd=33.6u ps=33.6u m=1
* device instance $111 r0 *1 33.3,40 pfet
XM__111 xtemp__NT xtemp__NT xtemp__NT xtemp__NT pfet_03v3 L=4u W=16u nf=1 ad=12.8p as=12.8p pd=33.6u ps=33.6u m=1
* device instance $112 r0 *1 41.4,42 pfet
XM__112 xtemp__NT xtemp__PB VDD VDD pfet_03v3 L=4u W=20u nf=1 ad=16p as=16p pd=41.6u ps=41.6u m=1
* device instance $113 r0 *1 108.1,34 pfet
XM__113 VDD VDD VDD VDD pfet_03v3 L=4u W=4u nf=1 ad=3.2p as=3.2p pd=9.6u ps=9.6u m=1
* device instance $114 r0 *1 114.2,34 pfet
XM__114 xtemp__M1D xtemp__PG VDD VDD pfet_03v3 L=4u W=4u nf=1 ad=3.2p as=3.2p pd=9.6u ps=9.6u m=1
* device instance $115 r0 *1 118.8,34 pfet
XM__115 xtemp__NA xtemp__PCAS xtemp__M1D VDD pfet_03v3 L=1u W=4u nf=1 ad=3.2p as=3.2p pd=9.6u ps=9.6u m=1
* device instance $116 r0 *1 123.4,34 pfet
XM__116 xtemp__M2D xtemp__PG VDD VDD pfet_03v3 L=4u W=4u nf=1 ad=3.2p as=3.2p pd=9.6u ps=9.6u m=1
* device instance $117 r0 *1 128,34 pfet
XM__117 xtemp__NB xtemp__PCAS xtemp__M2D VDD pfet_03v3 L=1u W=4u nf=1 ad=3.2p as=3.2p pd=9.6u ps=9.6u m=1
* device instance $118 r0 *1 132.6,34 pfet
XM__118 xtemp__M3D xtemp__PG VDD VDD pfet_03v3 L=4u W=4u nf=1 ad=3.2p as=3.2p pd=9.6u ps=9.6u m=1
* device instance $119 r0 *1 137.2,34 pfet
XM__119 PTAT xtemp__PCAS xtemp__M3D VDD pfet_03v3 L=1u W=4u nf=1 ad=3.2p as=3.2p pd=9.6u ps=9.6u m=1
* device instance $120 r0 *1 140.3,34 pfet
XM__120 PTAT xtemp__PCAS xtemp__M3D VDD pfet_03v3 L=1u W=4u nf=1 ad=3.2p as=3.2p pd=9.6u ps=9.6u m=1
* device instance $121 r0 *1 144.9,34 pfet
XM__121 xtemp__M3D xtemp__PG VDD VDD pfet_03v3 L=4u W=4u nf=1 ad=3.2p as=3.2p pd=9.6u ps=9.6u m=1
* device instance $122 r0 *1 149.5,34 pfet
XM__122 xtemp__NB xtemp__PCAS xtemp__M2D VDD pfet_03v3 L=1u W=4u nf=1 ad=3.2p as=3.2p pd=9.6u ps=9.6u m=1
* device instance $123 r0 *1 154.1,34 pfet
XM__123 xtemp__M2D xtemp__PG VDD VDD pfet_03v3 L=4u W=4u nf=1 ad=3.2p as=3.2p pd=9.6u ps=9.6u m=1
* device instance $124 r0 *1 158.7,34 pfet
XM__124 xtemp__NA xtemp__PCAS xtemp__M1D VDD pfet_03v3 L=1u W=4u nf=1 ad=3.2p as=3.2p pd=9.6u ps=9.6u m=1
* device instance $125 r0 *1 163.3,34 pfet
XM__125 xtemp__M1D xtemp__PG VDD VDD pfet_03v3 L=4u W=4u nf=1 ad=3.2p as=3.2p pd=9.6u ps=9.6u m=1
* device instance $126 r0 *1 169.4,34 pfet
XM__126 VDD VDD VDD VDD pfet_03v3 L=4u W=4u nf=1 ad=3.2p as=3.2p pd=9.6u ps=9.6u m=1
* device instance $127 r0 *1 185.6,37 pfet
XM__127 xtemp__PG xtemp__PB VDD VDD pfet_03v3 L=4u W=10u nf=1 ad=8p as=8p pd=21.6u ps=21.6u m=1
* device instance $128 r0 *1 205.1,37 pfet
XM__128 xtemp__PB xtemp__PB VDD VDD pfet_03v3 L=4u W=10u nf=1 ad=8p as=8p pd=21.6u ps=21.6u m=1
* device instance $129 r0 *1 217.3,32.5 pfet
XM__129 xtemp__PCAS xtemp__PCAS VDD VDD pfet_03v3 L=8u W=1u nf=1 ad=0.8p as=0.8p pd=3.6u ps=3.6u m=1
* device instance $130 r0 *1 223.65,33 pfet
XM__130 xtemp__ENB RESETn VDD VDD pfet_03v3 L=0.5u W=2u nf=1 ad=1.6p as=1.6p pd=5.6u ps=5.6u m=1
* device instance $131 r0 *1 232.6,32.5 pfet
XM__131 xtemp__ND xtemp__PB VDD VDD pfet_03v3 L=8u W=1u nf=1 ad=0.8p as=0.8p pd=3.6u ps=3.6u m=1
* device instance $132 r0 *1 247.9,32.5 pfet
XM__132 xtemp__NR xtemp__PG VDD VDD pfet_03v3 L=4u W=1u nf=1 ad=0.8p as=0.8p pd=3.6u ps=3.6u m=1
* device instance $133 r0 *1 258.95,34 pfet
XM__133 xtemp__PG RESETn VDD VDD pfet_03v3 L=0.5u W=4u nf=1 ad=3.2p as=3.2p pd=9.6u ps=9.6u m=1
* device instance $134 r0 *1 523.35,-396 pfet
XM__134 xcmp__BIAS_OKB BIAS_OK VDD VDD pfet_03v3 L=0.5u W=2u nf=1 ad=1.6p as=1p pd=5.6u ps=5u m=1

* ---- interconnect parasitics: extracted from the layout ----
* One series R + one lumped C to substrate per net, from the deck's
* curated sheet-resistance / capacitance table (klt extract
* --parasitics). First order, not a field solve.
Rpar__10 xcmp__SNS xcmp__SNS__par 1614.04
Cpar__10 xcmp__SNS__par VSS 1.38696e-14
Rpar__11 xcmp__NBG xcmp__NBG__par 1516.96
Cpar__11 xcmp__NBG__par VSS 2.1326e-14
Rpar__12 xpor__PDN xpor__PDN__par 4808.76
Cpar__12 xpor__PDN__par VSS 5.60048e-14
Rpar__13 xpor__NDL xpor__NDL__par 4397.85
Cpar__13 xpor__NDL__par VSS 4.68548e-14
Rpar__14 xpor__PGDGB xpor__PGDGB__par 4001.16
Cpar__14 xpor__PGDGB__par VSS 3.84214e-14
Rpar__15 xpor__ND1 xpor__ND1__par 3938.54
Cpar__15 xpor__ND1__par VSS 3.69999e-14
Rpar__16 xpor__NTS xpor__NTS__par 3872.82
Cpar__16 xpor__NTS__par VSS 3.43245e-14
Rpar__17 xbias__NA xbias__NA__par 4857.57
Cpar__17 xbias__NA__par VSS 5.01637e-14
Rpar__18 xbias__NBTOP xbias__NBTOP__par 4760.17
Cpar__18 xbias__NBTOP__par VSS 4.62236e-14
Rpar__19 xbias__NBG xbias__NBG__par 4871.76
Cpar__19 xbias__NBG__par VSS 5.58514e-14
Rpar__21 xbias__NT xbias__NT__par 4684.59
Cpar__21 xbias__NT__par VSS 4.99518e-14
Rpar__22 xbias__N1 xbias__N1__par 4967.86
Cpar__22 xbias__N1__par VSS 5.97813e-14
Rpar__23 xbias__N2 xbias__N2__par 4814.58
Cpar__23 xbias__N2__par VSS 5.26042e-14
Rpar__24 xbias__NKM xbias__NKM__par 4876.89
Cpar__24 xbias__NKM__par VSS 5.79231e-14
Rpar__25 xbias__TOK xbias__TOK__par 4690.53
Cpar__25 xbias__TOK__par VSS 5.23505e-14
Rpar__26 xbias__NOKO xbias__NOKO__par 4792.42
Cpar__26 xbias__NOKO__par VSS 5.91619e-14
Rpar__27 xbias__NOKL xbias__NOKL__par 4884
Cpar__27 xbias__NOKL__par VSS 6.07943e-14
Rpar__28 xbias__NOKX xbias__NOKX__par 4848.41
Cpar__28 xbias__NOKX__par VSS 5.97519e-14
Rpar__29 xbias__KS1 xbias__KS1__par 4818.85
Cpar__29 xbias__KS1__par VSS 5.43306e-14
Rpar__30 xbias__KS2 xbias__KS2__par 4819.39
Cpar__30 xbias__KS2__par VSS 5.45486e-14
Rpar__31 xbias__KS3 xbias__KS3__par 4819.93
Cpar__31 xbias__KS3__par VSS 5.47667e-14
Rpar__32 xbias__KS4 xbias__KS4__par 4820.47
Cpar__32 xbias__KS4__par VSS 5.49848e-14
Rpar__33 xbias__NKG xbias__NKG__par 4848.05
Cpar__33 xbias__NKG__par VSS 5.7785e-14
Rpar__34 xcmp__VDDA xcmp__VDDA__par 1263.82
Cpar__34 xcmp__VDDA__par VSS 1.4679e-14
Rpar__35 xcmp__NA xcmp__NA__par 1384.85
Cpar__35 xcmp__NA__par VSS 1.58685e-14
Rpar__36 xcmp__CMPO xcmp__CMPO__par 1382.12
Cpar__36 xcmp__CMPO__par VSS 1.77667e-14
Rpar__37 xcmp__N1 xcmp__N1__par 1437.88
Cpar__37 xcmp__N1__par VSS 1.78661e-14
Rpar__38 xcmp__TN xcmp__TN__par 1261.13
Cpar__38 xcmp__TN__par VSS 1.35887e-14
Rpar__39 xcmp__SNSB xcmp__SNSB__par 1556.35
Cpar__39 xcmp__SNSB__par VSS 1.43923e-14
Rpar__40 xpor__NDGN xpor__NDGN__par 3871.38
Cpar__40 xpor__NDGN__par VSS 3.3743e-14
Rpar__41 xpor__NDG xpor__NDG__par 4004.42
Cpar__41 xpor__NDG__par VSS 3.80628e-14
Rpar__42 xpor__PGDG xpor__PGDG__par 4123.71
Cpar__42 xpor__PGDG__par VSS 4.18228e-14
Rpar__43 xpor__TIM xpor__TIM__par 3937.78
Cpar__43 xpor__TIM__par VSS 3.6691e-14
Rpar__44 xpor__TRIP xpor__TRIP__par 3994.48
Cpar__44 xpor__TRIP__par VSS 3.89569e-14
Rpar__45 xpor__NNAND xpor__NNAND__par 3874.26
Cpar__45 xpor__NNAND__par VSS 3.49061e-14
Rpar__46 xpor__NDGP xpor__NDGP__par 3871.02
Cpar__46 xpor__NDGP__par VSS 3.35976e-14
Rpar__47 xpor__RSTB xpor__RSTB__par 4010.47
Cpar__47 xpor__RSTB__par VSS 4.37315e-14
Rpar__6 xbias__PG xbias__PG__par 5084.01
Cpar__6 xbias__PG__par VSS 6.81472e-14
Rpar__7 xbias__PB xbias__PB__par 5396
Cpar__7 xbias__PB__par VSS 7.91681e-14
Rpar__8 xbias__NB xbias__NB__par 4747.43
Cpar__8 xbias__NB__par VSS 4.11174e-14
Rpar_BIAS_OK BIAS_OK BIAS_OK__par 6145.44
Cpar_BIAS_OK BIAS_OK__par VSS 6.27687e-14
Rpar_BIAS_OKB xcmp__BIAS_OKB xcmp__BIAS_OKB__par 1631.18
Cpar_BIAS_OKB xcmp__BIAS_OKB__par VSS 2.16593e-14
Rpar_CTAT CTAT CTAT__par 474.74
Cpar_CTAT CTAT__par VSS 2.71954e-14
Rpar_EN_RESETn RESETn RESETn__par 5439.86
Cpar_EN_RESETn RESETn__par VSS 7.42687e-14
Rpar_ENB xtemp__ENB xtemp__ENB__par 1686.12
Cpar_ENB xtemp__ENB__par VSS 3.61461e-14
Rpar_IBIAS IBIAS IBIAS__par 10576.2
Cpar_IBIAS IBIAS__par VSS 1.22084e-13
Rpar_M1D xtemp__M1D xtemp__M1D__par 1180.59
Cpar_M1D xtemp__M1D__par VSS 2.54308e-14
Rpar_M2D xtemp__M2D xtemp__M2D__par 1105.05
Cpar_M2D xtemp__M2D__par VSS 2.40399e-14
Rpar_M3D xtemp__M3D xtemp__M3D__par 1029.53
Cpar_M3D xtemp__M3D__par VSS 2.26489e-14
Rpar_N1 xtemp__N1 xtemp__N1__par 3844.1
Cpar_N1 xtemp__N1__par VSS 3.85894e-14
Rpar_N2 xtemp__N2 xtemp__N2__par 2240.79
Cpar_N2 xtemp__N2__par VSS 4.40329e-14
Rpar_NA xtemp__NA xtemp__NA__par 1928.77
Cpar_NA xtemp__NA__par VSS 2.90978e-14
Rpar_NB xtemp__NB xtemp__NB__par 1853.51
Cpar_NB xtemp__NB__par VSS 2.77069e-14
Rpar_NBG xtemp__NBG xtemp__NBG__par 1144.93
Cpar_NBG xtemp__NBG__par VSS 2.69461e-14
Rpar_ND xtemp__ND xtemp__ND__par 1476.21
Cpar_ND xtemp__ND__par VSS 3.44808e-14
Rpar_NR xtemp__NR xtemp__NR__par 1658.51
Cpar_NR xtemp__NR__par VSS 3.51105e-14
Rpar_NT xtemp__NT xtemp__NT__par 5050.55
Cpar_NT xtemp__NT__par VSS 7.57243e-14
Rpar_PB xtemp__PB xtemp__PB__par 3354.45
Cpar_PB xtemp__PB__par VSS 4.57031e-14
Rpar_PCAS xtemp__PCAS xtemp__PCAS__par 4257.78
Cpar_PCAS xtemp__PCAS__par VSS 5.14302e-14
Rpar_PG xtemp__PG xtemp__PG__par 4774.58
Cpar_PG xtemp__PG__par VSS 5.91151e-14
Rpar_POR_RAW POR_RAW POR_RAW__par 5256.94
Cpar_POR_RAW POR_RAW__par VSS 4.72218e-14
Rpar_PTAT PTAT PTAT__par 847.142
Cpar_PTAT PTAT__par VSS 3.05575e-14
Rpar_T0 xtemp__T0 xtemp__T0__par 1166.13
Cpar_T0 xtemp__T0__par VSS 3.95244e-14
Rpar_T1 xtemp__T1 xtemp__T1__par 1129.91
Cpar_T1 xtemp__T1__par VSS 3.93243e-14
Rpar_T2 xtemp__T2 xtemp__T2__par 1093.87
Cpar_T2 xtemp__T2__par VSS 3.91773e-14
Rpar_T3 xtemp__T3 xtemp__T3__par 1057.66
Cpar_T3 xtemp__T3__par VSS 3.89772e-14
Rpar_T4 xtemp__T4 xtemp__T4__par 1021.61
Cpar_T4 xtemp__T4__par VSS 3.88302e-14
Rpar_T5 xtemp__T5 xtemp__T5__par 522.434
Cpar_T5 xtemp__T5__par VSS 3.10047e-14
Rpar_VDD VDD VDD__par 11430
Cpar_VDD VDD__par VSS 3.3777e-13
Rpar_VREF VREF VREF__par 5992.96
Cpar_VREF VREF__par VSS 5.29876e-14
Rpar_VSS VSS VSS__par 3249.11
Cpar_VSS VSS__par VSS 1.47506e-12

* ---- non-MOS devices: IDEAL, verbatim from the schematic ----
* Nodes introduced by these devices alone (they exist in no
* extraction, so they carry no parasitics): xbias__EC, xbias__ER, xbias__NZ, xtemp__NC, xtemp__NZ
* from xbias (bias_core)
XQ1_xbias VSS VSS xbias__NA pnp_10p00x10p00 m=1
* from xbias (bias_core)
XRT_xbias xbias__NBTOP xbias__NB VSS ppolyf_u_3k r_width=2u r_length=17.5u m=1
* from xbias (bias_core)
XR1_xbias xbias__NB xbias__EC VSS ppolyf_u_3k r_width=2u r_length=350.0u m=1
* from xbias (bias_core)
XQ8A_xbias VSS VSS xbias__EC pnp_10p00x10p00 m=1
* from xbias (bias_core)
XQ8B_xbias VSS VSS xbias__EC pnp_10p00x10p00 m=1
* from xbias (bias_core)
XQ8C_xbias VSS VSS xbias__EC pnp_10p00x10p00 m=1
* from xbias (bias_core)
XQ8D_xbias VSS VSS xbias__EC pnp_10p00x10p00 m=1
* from xbias (bias_core)
XQ8E_xbias VSS VSS xbias__EC pnp_10p00x10p00 m=1
* from xbias (bias_core)
XQ8F_xbias VSS VSS xbias__EC pnp_10p00x10p00 m=1
* from xbias (bias_core)
XQ8G_xbias VSS VSS xbias__EC pnp_10p00x10p00 m=1
* from xbias (bias_core)
XQ8H_xbias VSS VSS xbias__EC pnp_10p00x10p00 m=1
* from xbias (bias_core)
XR2_xbias VREF xbias__ER VSS ppolyf_u_3k r_width=2u r_length=4104.0u m=1
* from xbias (bias_core)
XQR_xbias VSS VSS xbias__ER pnp_10p00x10p00 m=1
* from xbias (bias_core)
XCC_xbias xbias__PG xbias__NZ cap_mim_2f0_m3m4_noshield c_width=20u c_length=20u m=1
* from xbias (bias_core)
XRZ_xbias xbias__NZ xbias__N2 VSS ppolyf_u_3k r_width=2u r_length=1016.0u m=1
* from xbias (bias_core)
XCOK_xbias VDD xbias__NOKX cap_mim_2f0_m3m4_noshield c_width=6u c_length=6u m=1
* from xcmp (por_comparator)
XRTOP_xcmp xcmp__SNS VDD VSS ppolyf_u_3k r_width=2u r_length=7897.44u m=1
* from xcmp (por_comparator)
XRBOT_xcmp xcmp__SNSB xcmp__SNS VSS ppolyf_u_3k r_width=2u r_length=6769.23u m=1
* from xcmp (por_comparator)
XRHYS_xcmp VSS xcmp__SNSB VSS ppolyf_u_3k r_width=2u r_length=775.0u m=1
* from xpor (por_output_chain)
XCDG_xpor xpor__NDG VSS cap_mim_2f0_m3m4_noshield c_width=11u c_length=11u m=1
* from xpor (por_output_chain)
XCTIM_xpor xpor__TIM VSS cap_mim_2f0_m3m4_noshield c_width=28u c_length=28u m=4
* from xtemp (temp_core)
XCC_xtemp xtemp__PG xtemp__NZ cap_mim_2f0_m3m4_noshield c_width=12u c_length=12u m=1
* from xtemp (temp_core)
XRZ_xtemp xtemp__NZ xtemp__N2 VSS ppolyf_u r_width=2u r_length=1000u m=1
* from xtemp (temp_core)
XQ1_xtemp VSS VSS xtemp__NA pnp_10p00x10p00 m=1
* from xtemp (temp_core)
XQ8A_xtemp VSS VSS xtemp__NC pnp_10p00x10p00 m=1
* from xtemp (temp_core)
XQ8B_xtemp VSS VSS xtemp__NC pnp_10p00x10p00 m=1
* from xtemp (temp_core)
XQ8C_xtemp VSS VSS xtemp__NC pnp_10p00x10p00 m=1
* from xtemp (temp_core)
XQ8D_xtemp VSS VSS xtemp__NC pnp_10p00x10p00 m=1
* from xtemp (temp_core)
XQ8E_xtemp VSS VSS xtemp__NC pnp_10p00x10p00 m=1
* from xtemp (temp_core)
XQ8F_xtemp VSS VSS xtemp__NC pnp_10p00x10p00 m=1
* from xtemp (temp_core)
XQ8G_xtemp VSS VSS xtemp__NC pnp_10p00x10p00 m=1
* from xtemp (temp_core)
XQ8H_xtemp VSS VSS xtemp__NC pnp_10p00x10p00 m=1
* from xtemp (temp_core)
XR1_xtemp xtemp__NB xtemp__NC VSS ppolyf_u r_width=2u r_length=119.47u m=1
* from xtemp (temp_core)
XR2F_xtemp PTAT xtemp__T5 VSS ppolyf_u r_width=2u r_length=2652.6u m=1
* from xtemp (temp_core)
XR2T5_xtemp xtemp__T5 xtemp__T4 VSS ppolyf_u r_width=2u r_length=229.71u m=1
* from xtemp (temp_core)
XR2T4_xtemp xtemp__T4 xtemp__T3 VSS ppolyf_u r_width=2u r_length=114.69u m=1
* from xtemp (temp_core)
XR2T3_xtemp xtemp__T3 xtemp__T2 VSS ppolyf_u r_width=2u r_length=57.18u m=1
* from xtemp (temp_core)
XR2T2_xtemp xtemp__T2 xtemp__T1 VSS ppolyf_u r_width=2u r_length=28.42u m=1
* from xtemp (temp_core)
XR2T1_xtemp xtemp__T1 xtemp__T0 VSS ppolyf_u r_width=2u r_length=14.03u m=1
* from xtemp (temp_core)
XR2T0_xtemp xtemp__T0 VSS VSS ppolyf_u r_width=2u r_length=6.85u m=1
* from xtemp (temp_core)
XRISO_xtemp xtemp__NA CTAT VSS ppolyf_u r_width=2u r_length=111.05u m=1

.ends temp_por_top
