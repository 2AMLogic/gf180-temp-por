* por-output-chain-floor -- stimulus half of the testbench fragment.
*
* The other half is a verbatim copy of design/netlist/por_output_chain.spice,
* appended by sim/build_tb.py to produce tb_por_floor.spice. Edit THIS file
* (or the schematic), never the generated fragment.
*
* Netlist FRAGMENT: no .include / .lib / .temp / .control / .end -- the
* harness owns those. Parameters it supplies: vdd_val, vdd_nom, temp_c.
*
* WHAT THIS EXPERIMENT SUBSTANTIATES
*
* spec/target-spec.md#por-reset-valid-floor: V(RESETn) <= min(0.1*VDD, 0.3 V)
* into the reset-pulse load, for ALL VDD >= 0 V. This is the numeric row DR-004
* requires #12 to fill, and it is a genuinely hard requirement rather than a
* formality: as VDD -> 0 the on/off ratio of a MOSFET collapses towards 1
* (Ion/Ioff ~ exp(VDD/nVt), which is only 1.3x at VDD = 10 mV), so a biasing
* argument cannot deliver the 10x the row asks for. Only device GEOMETRY can,
* which is why XMON/XMOP are 20:1 in W/L and the release NAND is deliberately
* PMOS-heavy / NMOS-light.
*
* WHY A SLOW RAMP AND NOT A DC SWEEP
*
* A tran ramp is parameterisable against the harness's per-point vdd_val in a
* way a `dc` command inside the harness's control block is not, and it is the
* stronger evidence anyway: it exercises the same handoff DR-004 describes --
* assist-held below the comparator floor, comparator-driven above it -- rather
* than a sequence of unrelated DC solutions. The ramp is deliberately slow
* (~0.66 kV/s, three decades inside the ratified por-ramp-rate envelope) so
* every point is quasi-static; the first millisecond covers 0 -> 50 mV at
* ~0.1 mV resolution, which is where the leakage-divider argument is weakest
* and where a coarse sweep would simply miss the failure.
*
* TWO DUTS, BECAUSE THE REQUIREMENT IS "NOT GATED BY POR_RAW"
*
*   xdut1  POR_RAW held low         the specified case: the comparator is below
*                                   its floor and its output is not driving.
*   xdut2  POR_RAW driven to VDD    the pathological case DR-004 actually warns
*                                   about -- POR_RAW is "undefined" below the
*                                   comparator floor, so a below-floor assist
*                                   that quietly assumes it reads low is not an
*                                   assist. Checked only for VDD < 1.5 V: above
*                                   that the comparator has a floor and a real
*                                   decision, and DUT2's timer legitimately runs.

vsup vdd 0 PWL(0 0 1m 0.05 6m {vdd_val} 7m {vdd_val})

* IBIAS: bias_core's 0.5 uA reference, coming up with the rail (same model as
* sim/temp-core-startup/). Below ~1.5 V there is no bias core, which is exactly
* the regime this experiment is about.
Bib1 vdd nib1 i='500n*min(1, max(0, (v(vdd)-1.5)/0.5))'
vib1 nib1 ibias1 dc 0
Bib2 vdd nib2 i='500n*min(1, max(0, (v(vdd)-1.5)/0.5))'
vib2 nib2 ibias2 dc 0

vd1 vdd vdd1 dc 0
vd2 vdd vdd2 dc 0

vpr1 por_raw1 0 dc 0
Epr2 por_raw2 0 vdd 0 1

* por-reset-pulse measurement load: 5 pF, no DC load. The 1 Tohm is a solver
* aid, not a load -- at 3.63 V it is 3.6 pA, four orders below anything here.
Cl1 resetn1 0 5p
Rl1 resetn1 0 1T
Cl2 resetn2 0 5p
Rl2 resetn2 0 1T

xdut1 vdd1 0 ibias1 por_raw1 resetn1 por_output_chain
xdut2 vdd2 0 ibias2 por_raw2 resetn2 por_output_chain
