* extracted by klt extract --deck gf180mcu
* parasitic model (--parasitics):
* - capacitance: net-to-ground for every net's own (non-coupled) area/perimeter, plus net-to-net for the vertical-overlap coupling `coupling` describes below -- a coupled net pair gets a direct capacitor between their two hub nodes, not just capacitors to the deck's ground/substrate net
* - coupling: vertical overlap (crossover) unconditionally -- where one net's conductor on an adjacent metal level sits directly over another *distinct* net's conductor, that overlap area is charged between the two nets instead of to ground (issue #760) -- plus lateral (same-layer, sidewall) coupling, but only for a net pair naming one of the caller's declared `--critical-net` nets (issue #976): facing-edge length within that layer's own minimum-spacing lookback is charged between the two nets, *additively* (not deducted from either net's substrate fringe term, unlike the vertical case -- a known simplification). Any same-layer pair with neither side named `--critical-net`, and fringe shielding in general, are still not modelled
* - resistance: single lumped series resistance per net, distributed as a star across that net's device terminals (issue #592) -- not a per-segment, distributed RC ladder, *unless* `--distributed-rc` names this net via `--critical-net` (issue #977, Epic #709 Phase 2b): then the net's terminals are ordered along their approximate physical spread and its total R/C is broken into a chain of per-segment resistors (segment length proportional to inter-terminal distance) with a ground capacitor at each terminal node (proportional to its adjacent segment length/2), instead of one star hub -- still an approximation (terminal position is a device-placement proxy, not true per-segment routing geometry), but a strictly finer-grained one than the single-hub star
* - frequency: quasi-static -- one frequency-independent R and C per net; no skin effect, no distributed transmission-line behavior
.GLOBAL vsubs

* cell por_comparator
* pin BIAS_OK
* pin BIAS_OKB
* pin IBIAS
* pin POR_RAW
* pin VDD
* pin VREF
* pin VSS
.SUBCKT por_comparator BIAS_OK BIAS_OKB IBIAS POR_RAW VDD VREF VSS
* device instance $1 r0 *1 33.5,0.5 nfet
M$1 \$9__t1 \$12__t0 VSS__t2 VSS__t13 nfet L=10U W=1U AS=0.8P AD=0.8P PS=3.6U
+ PD=3.6U
* device instance $2 r0 *1 52.4,0.5 nfet
M$2 IBIAS__t2 BIAS_OKB__t2 VSS__t3 VSS__t14 nfet L=1U W=1U AS=0.8P AD=0.8P
+ PS=3.6U PD=3.6U
* device instance $3 r0 *1 62.45,0.5 nfet
M$3 \$7__t2 \$5__t1 VSS__t5 VSS__t15 nfet L=0.5U W=1U AS=0.8P AD=0.8P PS=3.6U
+ PD=3.6U
* device instance $4 r0 *1 65.55,0.5 nfet
M$4 POR_RAW__t0 \$7__t3 VSS__t7 VSS__t16 nfet L=0.5U W=1U AS=0.8P AD=0.8P
+ PS=3.6U PD=3.6U
* device instance $5 r0 *1 73.35,0.5 nfet
M$5 BIAS_OKB__t4 BIAS_OK__t0 VSS__t6 VSS__t17 nfet L=0.5U W=1U AS=0.5P AD=0.8P
+ PS=3U PD=3.6U
* device instance $6 r0 *1 21.8,1 nfet
M$6 \$4__t2 \$10__t2 \$9__t0 VSS__t18 nfet L=1U W=2U AS=1.6P AD=1.6P PS=5.6U
+ PD=5.6U
* device instance $7 r0 *1 25.4,1 nfet
M$7 \$5__t2 VREF__t0 \$9__t2 VSS__t19 nfet L=1U W=2U AS=1.6P AD=1.6P PS=5.6U
+ PD=5.6U
* device instance $8 r0 *1 42.1,1 nfet
M$8 IBIAS__t0 \$12__t1 VSS__t1 VSS__t21 nfet L=2U W=2U AS=1.6P AD=1.6P PS=5.6U
+ PD=5.6U
* device instance $9 r0 *1 45.95,1 nfet
M$9 IBIAS__t1 BIAS_OK__t2 \$12__t2 VSS__t22 nfet L=0.5U W=2U AS=1.6P AD=1.6P
+ PS=5.6U PD=5.6U
* device instance $10 r0 *1 49.05,1 nfet
M$10 \$12__t3 BIAS_OKB__t1 VSS__t8 VSS__t23 nfet L=0.5U W=2U AS=1.6P AD=1.6P
+ PS=5.6U PD=5.6U
* device instance $11 r0 *1 59.1,1 nfet
M$11 \$5__t3 BIAS_OKB__t3 VSS__t9 VSS__t20 nfet L=1U W=2U AS=1.6P AD=1.6P
+ PS=5.6U PD=5.6U
* device instance $12 r0 *1 55.75,5 nfet
M$12 \$14__t1 \$7__t1 VSS__t4 VSS__t24 nfet L=0.5U W=10U AS=8P AD=8P PS=21.6U
+ PD=21.6U
* device instance $13 r0 *1 11.35,1 pfet
M$13 \$7__t0 \$5__t0 VDD__t3 VDD__t4 pfet L=0.5U W=2U AS=1.6P AD=1.6P PS=5.6U
+ PD=5.6U
* device instance $14 r0 *1 14.45,1 pfet
M$14 POR_RAW__t1 \$7__t4 VDD__t9 VDD__t8 pfet L=0.5U W=2U AS=1.6P AD=1.6P
+ PS=5.6U PD=5.6U
* device instance $15 r0 *1 1.3,2 pfet
M$15 \$4__t0 \$4__t1 \$3__t0 VDD__t0 pfet L=1U W=4U AS=3.2P AD=3.2P PS=9.6U
+ PD=9.6U
* device instance $16 r0 *1 4.9,2 pfet
M$16 \$5__t4 \$4__t3 \$3__t2 VDD__t10 pfet L=1U W=4U AS=3.2P AD=3.2P PS=9.6U
+ PD=9.6U
* device instance $17 r0 *1 8.25,2 pfet
M$17 \$3__t1 BIAS_OKB__t0 VDD__t1 VDD__t2 pfet L=0.5U W=4U AS=3.2P AD=3.2P
+ PS=9.6U PD=9.6U
* device instance $18 r0 *1 73.35,4 pfet
M$18 BIAS_OKB__t5 BIAS_OK__t1 VDD__t5 VDD__t6 pfet L=0.5U W=2U AS=1P AD=1.6P
+ PS=5U PD=5.6U
* device instance $19 r0 *1 309,68.04 ppolyf_u_1k
R$19 \$14__t0 \$10__t1 VSS__t10 3384615 ppolyf_u_1k L=6769.23U W=2U
* device instance $20 r0 *1 410,18.87 ppolyf_u_1k
R$20 VSS__t0 \$14__t2 VSS__t11 387500 ppolyf_u_1k L=775U W=2U
* device instance $21 r0 *1 157,73.45 ppolyf_u_1k
R$21 \$10__t0 VDD__t7 VSS__t12 3948720 ppolyf_u_1k L=7897.44U W=2U
* device instance _10_t0 r0 *1 0,0
R_10_t0 \$10__t0 \$10 122.891188735
* device instance _10_t1 r0 *1 0,0
R_10_t1 \$10__t1 \$10 684.260298411
* device instance _10_t2 r0 *1 0,0
R_10_t2 \$10__t2 \$10 686.317212854
* device instance _10 r0 *1 0,0
C_10 \$10 vsubs 5.2676745e-14
* device instance _12_t0 r0 *1 0,0
R_12_t0 \$12__t0 \$12 715.139441326
* device instance _12_t1 r0 *1 0,0
R_12_t1 \$12__t1 \$12 44.0457601943
* device instance _12_t2 r0 *1 0,0
R_12_t2 \$12__t2 \$12 257.887617601
* device instance _12_t3 r0 *1 0,0
R_12_t3 \$12__t3 \$12 499.88258088
* device instance _12 r0 *1 0,0
C_12 \$12 vsubs 2.1326008e-14
* device instance _14_t0 r0 *1 0,0
R_14_t0 \$14__t0 \$14 212.505970377
* device instance _14_t1 r0 *1 0,0
R_14_t1 \$14__t1 \$14 688.024299088
* device instance _14_t2 r0 *1 0,0
R_14_t2 \$14__t2 \$14 513.046030534
* device instance _14 r0 *1 0,0
C_14 \$14 vsubs 4.4264354e-14
* device instance _3_t0 r0 *1 0,0
R_3_t0 \$3__t0 \$3 631.9122
* device instance _3_t1 r0 *1 0,0
R_3_t1 \$3__t1 \$3 616.937977251
* device instance _3_t2 r0 *1 0,0
R_3_t2 \$3__t2 \$3 14.9742227488
* device instance _3 r0 *1 0,0
C_3 \$3 vsubs 1.4679011e-14
* device instance _4_t0 r0 *1 0,0
R_4_t0 \$4__t0 \$4 288.034386996
* device instance _4_t1 r0 *1 0,0
R_4_t1 \$4__t1 \$4 288.034386996
* device instance _4_t2 r0 *1 0,0
R_4_t2 \$4__t2 \$4 692.332138375
* device instance _4_t3 r0 *1 0,0
R_4_t3 \$4__t3 \$4 116.445087634
* device instance _4 r0 *1 0,0
C_4 \$4 vsubs 1.5868526e-14
* device instance _5_t0 r0 *1 0,0
R_5_t0 \$5__t0 \$5 261.418858782
* device instance _5_t1 r0 *1 0,0
R_5_t1 \$5__t1 \$5 366.105615344
* device instance _5_t2 r0 *1 0,0
R_5_t2 \$5__t2 \$5 88.9071013133
* device instance _5_t3 r0 *1 0,0
R_5_t3 \$5__t3 \$5 324.899769804
* device instance _5_t4 r0 *1 0,0
R_5_t4 \$5__t4 \$5 340.793554757
* device instance _5 r0 *1 0,0
C_5 \$5 vsubs 1.7766709e-14
* device instance _7_t0 r0 *1 0,0
R_7_t0 \$7__t0 \$7 377.193158999
* device instance _7_t1 r0 *1 0,0
R_7_t1 \$7__t1 \$7 175.868361694
* device instance _7_t2 r0 *1 0,0
R_7_t2 \$7__t2 \$7 253.833596266
* device instance _7_t3 r0 *1 0,0
R_7_t3 \$7__t3 \$7 292.041043747
* device instance _7_t4 r0 *1 0,0
R_7_t4 \$7__t4 \$7 338.946339293
* device instance _7 r0 *1 0,0
C_7 \$7 vsubs 1.7866109e-14
* device instance _9_t0 r0 *1 0,0
R_9_t0 \$9__t0 \$9 486.762381087
* device instance _9_t1 r0 *1 0,0
R_9_t1 \$9__t1 \$9 630.394143252
* device instance _9_t2 r0 *1 0,0
R_9_t2 \$9__t2 \$9 143.96957566
* device instance _9 r0 *1 0,0
C_9 \$9 vsubs 1.3588667e-14
* device instance BIAS_OK_t0 r0 *1 0,0
RBIAS_OK_t0 BIAS_OK__t0 BIAS_OK 363.218515086
* device instance BIAS_OK_t1 r0 *1 0,0
RBIAS_OK_t1 BIAS_OK__t1 BIAS_OK 369.383580086
* device instance BIAS_OK_t2 r0 *1 0,0
RBIAS_OK_t2 BIAS_OK__t2 BIAS_OK 719.565404828
* device instance BIAS_OK r0 *1 0,0
CBIAS_OK BIAS_OK vsubs 1.5010689e-14
* device instance BIAS_OKB_t0 r0 *1 0,0
RBIAS_OKB_t0 BIAS_OKB__t0 BIAS_OKB 744.308889961
* device instance BIAS_OKB_t1 r0 *1 0,0
RBIAS_OKB_t1 BIAS_OKB__t1 BIAS_OKB 59.9080526262
* device instance BIAS_OKB_t2 r0 *1 0,0
RBIAS_OKB_t2 BIAS_OKB__t2 BIAS_OKB 17.0676522536
* device instance BIAS_OKB_t3 r0 *1 0,0
RBIAS_OKB_t3 BIAS_OKB__t3 BIAS_OKB 109.722398109
* device instance BIAS_OKB_t4 r0 *1 0,0
RBIAS_OKB_t4 BIAS_OKB__t4 BIAS_OKB 349.031750011
* device instance BIAS_OKB_t5 r0 *1 0,0
RBIAS_OKB_t5 BIAS_OKB__t5 BIAS_OKB 351.14495704
* device instance BIAS_OKB r0 *1 0,0
CBIAS_OKB BIAS_OKB vsubs 2.1654538e-14
* device instance IBIAS_t0 r0 *1 0,0
RIBIAS_t0 IBIAS__t0 IBIAS 533.695252733
* device instance IBIAS_t1 r0 *1 0,0
RIBIAS_t1 IBIAS__t1 IBIAS 99.7987141232
* device instance IBIAS_t2 r0 *1 0,0
RIBIAS_t2 IBIAS__t2 IBIAS 632.489533144
* device instance IBIAS r0 *1 0,0
CIBIAS IBIAS vsubs 1.5551286e-14
* device instance POR_RAW_t0 r0 *1 0,0
RPOR_RAW_t0 POR_RAW__t0 POR_RAW 630.2627
* device instance POR_RAW_t1 r0 *1 0,0
RPOR_RAW_t1 POR_RAW__t1 POR_RAW 630.2627
* device instance POR_RAW r0 *1 0,0
CPOR_RAW POR_RAW vsubs 1.3389027e-14
* device instance VDD_t0 r0 *1 0,0
RVDD_t0 VDD__t0 VDD 5.9041895961
* device instance VDD_t1 r0 *1 0,0
RVDD_t1 VDD__t1 VDD 4.71508973949
* device instance VDD_t2 r0 *1 0,0
RVDD_t2 VDD__t2 VDD 4.71508973949
* device instance VDD_t3 r0 *1 0,0
RVDD_t3 VDD__t3 VDD 4.24096746289
* device instance VDD_t4 r0 *1 0,0
RVDD_t4 VDD__t4 VDD 4.24096746289
* device instance VDD_t5 r0 *1 0,0
RVDD_t5 VDD__t5 VDD 6.87650413981
* device instance VDD_t6 r0 *1 0,0
RVDD_t6 VDD__t6 VDD 6.87650413981
* device instance VDD_t7 r0 *1 0,0
RVDD_t7 VDD__t7 VDD 24.3165014744
* device instance VDD_t8 r0 *1 0,0
RVDD_t8 VDD__t8 VDD 3.72828176386
* device instance VDD_t9 r0 *1 0,0
RVDD_t9 VDD__t9 VDD 3.72828176386
* device instance VDD_t10 r0 *1 0,0
RVDD_t10 VDD__t10 VDD 5.28662271739
* device instance VDD r0 *1 0,0
CVDD VDD vsubs 5.2337816e-14
* device instance VREF_t0 r0 *1 0,0
RVREF_t0 VREF__t0 VREF 1314.9134
* device instance VREF r0 *1 0,0
CVREF VREF vsubs 1.1576327e-14
* device instance VSS_t0 r0 *1 0,0
RVSS_t0 VSS__t0 VSS 21.9623916049
* device instance VSS_t1 r0 *1 0,0
RVSS_t1 VSS__t1 VSS 3.68926797329
* device instance VSS_t2 r0 *1 0,0
RVSS_t2 VSS__t2 VSS 4.28730713656
* device instance VSS_t3 r0 *1 0,0
RVSS_t3 VSS__t3 VSS 2.98646338292
* device instance VSS_t4 r0 *1 0,0
RVSS_t4 VSS__t4 VSS 2.71447557922
* device instance VSS_t5 r0 *1 0,0
RVSS_t5 VSS__t5 VSS 2.3015019586
* device instance VSS_t6 r0 *1 0,0
RVSS_t6 VSS__t6 VSS 1.57310764032
* device instance VSS_t7 r0 *1 0,0
RVSS_t7 VSS__t7 VSS 2.09215843778
* device instance VSS_t8 r0 *1 0,0
RVSS_t8 VSS__t8 VSS 3.21060999989
* device instance VSS_t9 r0 *1 0,0
RVSS_t9 VSS__t9 VSS 2.52186312651
* device instance VSS_t10 r0 *1 0,0
RVSS_t10 VSS__t10 VSS 15.4918826332
* device instance VSS_t11 r0 *1 0,0
RVSS_t11 VSS__t11 VSS 21.9623916049
* device instance VSS_t12 r0 *1 0,0
RVSS_t12 VSS__t12 VSS 6.28602125058
* device instance VSS_t13 r0 *1 0,0
RVSS_t13 VSS__t13 VSS 4.28730713656
* device instance VSS_t14 r0 *1 0,0
RVSS_t14 VSS__t14 VSS 2.98646338292
* device instance VSS_t15 r0 *1 0,0
RVSS_t15 VSS__t15 VSS 2.3015019586
* device instance VSS_t16 r0 *1 0,0
RVSS_t16 VSS__t16 VSS 2.09215843778
* device instance VSS_t17 r0 *1 0,0
RVSS_t17 VSS__t17 VSS 1.57310764032
* device instance VSS_t18 r0 *1 0,0
RVSS_t18 VSS__t18 VSS 5.09283406728
* device instance VSS_t19 r0 *1 0,0
RVSS_t19 VSS__t19 VSS 4.84353174536
* device instance VSS_t20 r0 *1 0,0
RVSS_t20 VSS__t20 VSS 2.52186312651
* device instance VSS_t21 r0 *1 0,0
RVSS_t21 VSS__t21 VSS 3.68926797329
* device instance VSS_t22 r0 *1 0,0
RVSS_t22 VSS__t22 VSS 3.42393662359
* device instance VSS_t23 r0 *1 0,0
RVSS_t23 VSS__t23 VSS 3.21060999989
* device instance VSS_t24 r0 *1 0,0
RVSS_t24 VSS__t24 VSS 2.71447557922
* device instance VSS r0 *1 0,0
CVSS VSS vsubs 1.99238424e-13
* device instance cc__10__14 r0 *1 0,0
Ccc__10__14 \$10 \$14 1.8889e-17
* device instance cc__10_BIAS_OK r0 *1 0,0
Ccc__10_BIAS_OK \$10 BIAS_OK 9.444e-18
* device instance cc__10_BIAS_OKB r0 *1 0,0
Ccc__10_BIAS_OKB \$10 BIAS_OKB 9.444e-18
* device instance cc__10_VDD r0 *1 0,0
Ccc__10_VDD \$10 VDD 9.444e-18
* device instance cc__14_VDD r0 *1 0,0
Ccc__14_VDD \$14 VDD 9.444e-18
* device instance vsubs_dctie r0 *1 0,0
Rvsubs_dctie vsubs 0 1e+12
.ENDS por_comparator
