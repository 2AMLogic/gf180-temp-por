* por-output-chain-deglitch asymmetry probe -- schematic @ ss / -40 C / 2.97 V -- GENERATED by run_deglitch_asym_probe.py, do not edit
* pdk=gf180mcuD@c6d73a35f524070e85faff4a6a9eef49553ebc2b

.param vdd_val=2.97
.param stop_s=0.00102

.include "/home/ubuntu/.volare/gf180mcuD/libs.tech/ngspice/design.ngspice"
.lib "/home/ubuntu/.volare/gf180mcuD/libs.tech/ngspice/sm141064.ngspice" ss
.lib "/home/ubuntu/.volare/gf180mcuD/libs.tech/ngspice/sm141064.ngspice" res_ss
.lib "/home/ubuntu/.volare/gf180mcuD/libs.tech/ngspice/sm141064.ngspice" bjt_ss
.lib "/home/ubuntu/.volare/gf180mcuD/libs.tech/ngspice/sm141064.ngspice" diode_ss
.lib "/home/ubuntu/.volare/gf180mcuD/libs.tech/ngspice/sm141064.ngspice" moscap_ss
.lib "/home/ubuntu/.volare/gf180mcuD/libs.tech/ngspice/sm141064.ngspice" mimcap_ss

.temp -40.0
.options reltol=1e-5
.options abstol=1e-15
.options vntol=1e-8
.options method=gear

.include "../deglitch_asym_probe.spice"
.include "dut_schematic.spice"

.tran 2e-08 {stop_s}

.control
set numdgt=10
set noaskquit
run
wrdata trace.csv v(por_raw) v(xdut1.ndg) v(xdut1.ndgp) v(xdut1.ndgn) v(xdut1.pgdg)
.endc
.end
