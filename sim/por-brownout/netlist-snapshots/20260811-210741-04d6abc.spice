* Frozen netlist snapshot for record 20260811-210741-04d6abc
* source     : sim/por-brownout/testbench-postlayout/tb_por_brownout_postlayout.spice
* sha256     : d1dcdee2ef6af32d367db8fa85cff4d78b4e05bfafca118a72c0398c2209993b
* This is a verbatim copy taken at record time. Do not edit.
* tb_por_brownout_postlayout -- GENERATED by sim/build_tb.py
* Do not edit. Sources:
*   sim/por-brownout/testbench/stimulus.spice
*   layout/postlayout/temp_por_top.spice  (sha256 b04ec65d9bdcde5b8e814483cf93f037bbe421a7aafaf143c36a2fb0d8bd3db7)
* Regenerate with:
*   python3 sim/build_tb.py

* por-brownout -- stimulus half of the testbench fragment.
*
* The other half is a verbatim copy of design/netlist/temp_por_top.spice,
* appended by sim/build_tb.py to produce tb_por_brownout.spice. Edit THIS
* file (or the schematics), never the generated fragment.
*
* Netlist FRAGMENT: no .include / .lib / .temp / .control / .end -- the
* harness owns those. Parameters it supplies: vdd_val, vdd_nom, temp_c.
*
* WHAT THIS EXPERIMENT SUBSTANTIATES
*
* spec/target-spec.md#por-brownout: a dip that (a) takes VDD below
* VPOR-downarrow,min = 2.22 V and (b) stays below VPOR-downarrow for
* >= T_dip,min = 30 us must re-assert RESETn and regenerate the FULL
* [por-reset-pulse] (>=1 ms), on the full four-cell assembly with bias_core's
* real (starved, corner-dependent) recovery dynamics in the loop -- not the
* idealised-bias por_output_chain-only deglitch check
* sim/por-output-chain-deglitch/ already ran.
*
* T_dip,min WAS 10 us UNTIL DR-027 (#251). It is now 30 us: the deglitch dwell
* the cell actually achieves at the current the assembly really delivers to it
* (91.0251 nA, DR-024), measured across the full grid at both netlist levels
* by sim/por-output-chain-deglitch/control/run_dwell_sweep.py (slowest crossing
* 23.110 us, +29.8 % margin). This deck's dwell is UNCHANGED at 50 us, which is
* 1.67x the new value and still unambiguously qualifying under clause (b) --
* and the quantity clause (b) is actually written against here is the ~51 us
* the RAIL spends below VPOR-downarrow,min, not the programmed dwell. What did
* change is where resetn_floor_in_dip_mv is sampled: at 20.03 ms it sat 29 us
* into the dip, i.e. BEFORE a qualifying dwell had even elapsed under the new
* T_dip,min, so it now samples at 20.045 ms (44 us in). See tb.json.
*
* WHAT THIS DECK STILL DOES NOT DEMONSTRATE, AND WHY
*
* Clause (c) of the same row -- dVDD/dt|fall,max = 2.30 mV/us (DR-011, re-cost
* post-layout by DR-019) -- is violated by this deck by ~1000x: its dip edge is
* 1 us, i.e. 2300 mV/us. That is deliberate and predates DR-027: the 1 us edge
* is the edge the row's own root-cause investigation (#55) was run at, and
* sim/por-brownout/control/results.md part E shows that at THIS edge no dwell
* re-asserts RESETn inside the dip -- 5 ms (100x this deck's dwell, 167x
* T_dip,min) still does not. So this deck's FAIL is a clause-(c) failure, not a
* clause-(b) one, and re-costing T_dip,min neither fixes it nor is meant to.
* The assembly-level evidence that a dip meeting ALL THREE clauses re-asserts
* and regenerates the pulse is sim/por-brownout-slew/'s 2.30 mV/us rung
* (81/81 at both netlist levels), whose own dip holds the rail below
* VPOR-downarrow,min for ~1.1 ms -- 37x T_dip,min(new).
*
* It also carries the full-assembly confirmation of
* spec/target-spec.md#por-reset-pulse that #14 owes: the >=1 ms minimum was
* measured at the single-cell level by #12 (sim/por-output-chain-pulse/, min
* 4.21535 ms at ff/-40C/2.97V), and t_pulse_regen_ms below is the same
* quantity measured end to end on the assembled block, in the brownout
* context, at every corner -- including the observed MAXIMUM, which the
* ratified row explicitly asks #14 to record ("#14 records the observed max
* so a maximum can be added later on evidence").
*
* WHY A DEEP DIP: design/bias_core.md's "starved-loop window" documents that
* a FULL rail collapse leaves BIAS_OK reading a false valid for
* 326-1567 us while the reference loop crawls back (measured on bias_core
* alone, idealised load). This deck's dip goes to 1.0 V -- below every
* corner's comparator/reference operating floor (sim/por-comparator-
* designer-check/'s below-floor probes) -- so it exercises the SAME
* recovery path a full collapse does, but from a bounded starting point
* rather than 0 V, matching "brownout" rather than "power-cycle". If the
* starved-loop window shows up here as a longer-than-#12's-idealised-record
* reassert or release delay, that is the ALREADY-OWNED, ALREADY-TRACKED
* finding design/bias_core.md assigns to #1/#14 -- record it, do not
* root-cause it fresh (see design/bias_core.md, "The starved-loop window").
*
* TIMESTEP: the manifest asks for `tran 20u 55m`, i.e. a 20 us ceiling on the
* step in QUIET regions only. Both dip edges are PWL breakpoints ngspice
* lands on exactly, and the rail slews 2.0-2.6 V in 1 us across each of
* them, so local truncation error drives the step orders of magnitude below
* the ceiling through the whole disturbance -- which is where
* `t_reassert_us` (bounded at 50 us) is resolved. The ceiling only governs
* the two long static holds, where the full four-cell assembly would
* otherwise spend most of its ~12 ms-per-step solve cost resolving nothing.
*
* PAD LOAD: 1 pF plus a 1 Tohm DC leak on each of PTAT and CTAT, matching
* sim/temp-por-top-release/ and sim/temp-accuracy-vt/ exactly. The resistors
* are not a model of anything physical -- they are the DC reference the two
* analogue pads need in the state this deck spends most of its time in.
* While RESETn is asserted temp_core is disabled and its outputs are high
* impedance (DR-010's disabled-consumer contract), so without them PTAT and
* CTAT are capacitively coupled floating nodes, and ngspice's local
* truncation error control collapses the timestep trying to track them: an
* early revision of these decks, identical but for these four lines, ran
* >450 s of CPU per PVT point without completing, against ~36 s for the
* comparable 30 ms transient in sim/temp-por-top-release/. 1 Tohm at a
* ~1.3 V pad is 1.3 pA, four to five orders of magnitude below the block's
* own nanoamp-scale currents, so it references the node without loading it.
*
* ONE DUT, ONE TRAN, staged as a timeline (the multi-stage idiom
* sim/bias-core-startup/'s `xbo` branch already uses):
*
*   0    ->  1 ms   cold start: VDD ramps 0 -> vdd_val in 1 ms (2970-3630
*                    V/s, inside the ratified por-ramp-rate envelope and the
*                    exact cold start sim/temp-por-top-release/ validates
*                    releases correctly at all 81 points).
*    1   -> 20 ms   held at vdd_val -- rail settled, RESETn released.
*                    sim/temp-por-top-release/ measures release complete by
*                    16.95 ms at the slowest corner (ss/-40C/3.63V) off this
*                    same 1 ms ramp, so 20 ms leaves 3 ms of margin.
*   20   -> 20.001 ms   VDD dips from vdd_val to 1.0 V over 1 us.
*   20.001 -> 20.051 ms  held at 1.0 V for 50 us -- 1.67x T_dip,min = 30 us
*                    (DR-027, #251), and above the 6.14-23.11 us deglitch
*                    dwell sim/por-output-chain-deglitch/control/ measures at
*                    the cell level at the REAL delivered bias across both
*                    netlists, so this is unambiguously a QUALIFYING dip under
*                    clauses (a) and (b), not a glitch (that is
*                    sim/por-glitch/'s job). Clause (c) is a different matter
*                    -- see "WHAT THIS DECK STILL DOES NOT DEMONSTRATE" above.
*   20.051 -> 20.052 ms  VDD recovers from 1.0 V to vdd_val over 1 us.
*   20.052 -> 55 ms  held at vdd_val -- RESETn must have re-asserted during
*                    the dip and must now regenerate a full
*                    [por-reset-pulse] (>=1 ms) before releasing again. The
*                    35 ms of recovery observation is sized off the
*                    end-to-end release time sim/temp-por-top-release/
*                    measures on this same assembly (5.6-17.0 ms) plus the
*                    starved-loop window design/bias_core.md measures after
*                    a collapse (up to 1.57 ms) -- i.e. roughly 2x the
*                    slowest expected recovery, so a corner that takes
*                    longer than expected still lands inside the run and is
*                    measured rather than silently reported as "no data".

vsup vdd 0 PWL(
+ 0        0
+ 1m       {vdd_val}
+ 20m      {vdd_val}
+ 20.001m  1.0
+ 20.051m  1.0
+ 20.052m  {vdd_val}
+ 55m      {vdd_val}
+ )

Cpp ptat 0 1p
Cpc ctat 0 1p
Rlp ptat 0 1T
Rlc ctat 0 1T
Crn resetn 0 5p

xdut vdd 0 ptat ctat resetn temp_por_top

* temp_por_top -- post-layout netlist
* GENERATED by layout/postlayout.py -- do not edit.
*
* FROM THE LAYOUT: every device and its dimensions, the whole
*   topology, and first-order interconnect R/C on 136/159 nets
*   (sigma 5880.2 fF). klt 0.2.0, deck gf180mcu,
*   GDS sha256 cfa19694b87948b2...
* Net names are the schematic's, restored through klt lvs's own net
*   correspondence -- match, 159/159 nets, every one paired.
*
* NOT FROM THE LAYOUT -- see layout/postlayout/AUDIT.md:
*   23 body/plate net(s) tied to the net the schematic puts
*   them on. The extraction deck's connectivity stack does not reach
*   an Nwell, a substrate ring, a bipolar base well or a MiM plate,
*   so they extract isolated and would otherwise float.
*   XCC (cap_mim_2f0_m3m4_noshield) is IDEAL -- not drawn in this cell's layout -- reserved floor area.
*
.subckt temp_por_top VDD VSS PTAT CTAT RESETn

* --- schematic-ideal, not drawn ---
XIDEAL1 xtemp__PG xtemp__NZ cap_mim_2f0_m3m4_noshield c_width=12u c_length=12u

* --- drawn devices ---
X1 xbias__NBG xbias__NBG VSS VSS nfet_03v3 L=4u W=2u nf=1 ad=1.6p as=1.6p pd=5.6u ps=5.6u m=1
X2 xbias__PB xbias__NBG VSS VSS nfet_03v3 L=4u W=2u nf=1 ad=1.6p as=1.6p pd=5.6u ps=5.6u m=1
X3 xbias__N1 xbias__N1 VSS VSS nfet_03v3 L=8u W=4u nf=1 ad=3.2p as=3.2p pd=9.6u ps=9.6u m=1
X4 xbias__N2 xbias__N1 VSS VSS nfet_03v3 L=8u W=4u nf=1 ad=3.2p as=3.2p pd=9.6u ps=9.6u m=1
X5 xbias__PG xbias__N2 VSS VSS nfet_03v3 L=8u W=8u nf=1 ad=6.4p as=6.4p pd=17.6u ps=17.6u m=1
X6 VDD VDD xbias__KS1 VSS nfet_03v3 L=8u W=1u nf=1 ad=0.8p as=0.8p pd=3.6u ps=3.6u m=1
X7 xbias__KS1 xbias__KS1 xbias__KS2 VSS nfet_03v3 L=8u W=1u nf=1 ad=0.8p as=0.8p pd=3.6u ps=3.6u m=1
X8 xbias__KS2 xbias__KS2 xbias__KS3 VSS nfet_03v3 L=8u W=1u nf=1 ad=0.8p as=0.8p pd=3.6u ps=3.6u m=1
X9 xbias__KS3 xbias__KS3 xbias__KS4 VSS nfet_03v3 L=8u W=1u nf=1 ad=0.8p as=0.8p pd=3.6u ps=3.6u m=1
X10 xbias__KS4 xbias__KS4 xbias__NKG VSS nfet_03v3 L=8u W=1u nf=1 ad=0.8p as=0.8p pd=3.6u ps=3.6u m=1
X11 xbias__NKM xbias__NKM VSS VSS nfet_03v3 L=4u W=2u nf=1 ad=1.6p as=1.6p pd=5.6u ps=5.6u m=1
X12 xbias__NKG xbias__NKM VSS VSS nfet_03v3 L=4u W=8u nf=1 ad=6.4p as=6.4p pd=17.6u ps=17.6u m=1
X13 xbias__PG xbias__NKG VSS VSS nfet_03v3 L=4u W=1u nf=1 ad=0.8p as=0.8p pd=3.6u ps=3.6u m=1
X14 xbias__NOKL xbias__NOKL VSS VSS nfet_03v3 L=4u W=2u nf=1 ad=1.6p as=1.6p pd=5.6u ps=5.6u m=1
X15 xbias__NOKO xbias__NOKL VSS VSS nfet_03v3 L=4u W=2u nf=1 ad=1.6p as=1.6p pd=5.6u ps=5.6u m=1
X16 xbias__NOKO xbias__NKG VSS VSS nfet_03v3 L=1u W=2u nf=1 ad=1.6p as=1.6p pd=5.6u ps=5.6u m=1
X17 xbias__NOKX xbias__NOKO VSS VSS nfet_03v3 L=4u W=2u nf=1 ad=1.6p as=1.6p pd=5.6u ps=5.6u m=1
X18 BIAS_OK xbias__NOKX VSS VSS nfet_03v3 L=0.5u W=4u nf=1 ad=3.2p as=3.2p pd=9.6u ps=9.6u m=1
X19 xcmp__NA xcmp__SNS xcmp__TN VSS nfet_03v3 L=1u W=2u nf=1 ad=1.6p as=1.6p pd=5.6u ps=5.6u m=1
X20 xcmp__CMPO VREF xcmp__TN VSS nfet_03v3 L=1u W=2u nf=1 ad=1.6p as=1.6p pd=5.6u ps=5.6u m=1
X21 xcmp__TN xcmp__NBG VSS VSS nfet_03v3 L=10u W=1u nf=1 ad=0.8p as=0.8p pd=3.6u ps=3.6u m=1
X22 IBIAS xcmp__NBG VSS VSS nfet_03v3 L=2u W=2u nf=1 ad=1.6p as=1.6p pd=5.6u ps=5.6u m=1
X23 IBIAS BIAS_OK xcmp__NBG VSS nfet_03v3 L=0.5u W=2u nf=1 ad=1.6p as=1.6p pd=5.6u ps=5.6u m=1
X24 xcmp__NBG xcmp__BIAS_OKB VSS VSS nfet_03v3 L=0.5u W=2u nf=1 ad=1.6p as=1.6p pd=5.6u ps=5.6u m=1
X25 IBIAS xcmp__BIAS_OKB VSS VSS nfet_03v3 L=1u W=1u nf=1 ad=0.8p as=0.8p pd=3.6u ps=3.6u m=1
X26 xcmp__SNSB xcmp__N1 VSS VSS nfet_03v3 L=0.5u W=10u nf=1 ad=8p as=8p pd=21.6u ps=21.6u m=1
X27 xcmp__CMPO xcmp__BIAS_OKB VSS VSS nfet_03v3 L=1u W=2u nf=1 ad=1.6p as=1.6p pd=5.6u ps=5.6u m=1
X28 xcmp__N1 xcmp__CMPO VSS VSS nfet_03v3 L=0.5u W=1u nf=1 ad=0.8p as=0.8p pd=3.6u ps=3.6u m=1
X29 POR_RAW xcmp__N1 VSS VSS nfet_03v3 L=0.5u W=1u nf=1 ad=0.8p as=0.8p pd=3.6u ps=3.6u m=1
X30 xcmp__BIAS_OKB BIAS_OK VSS VSS nfet_03v3 L=0.5u W=1u nf=1 ad=0.8p as=0.5p pd=3.6u ps=3u m=1
X31 IBIAS IBIAS VSS VSS nfet_03v3 L=4u W=4u nf=1 ad=3.2p as=3.2p pd=9.6u ps=9.6u m=1
X32 xpor__PDN IBIAS VSS VSS nfet_03v3 L=25u W=0.5u nf=1 ad=0.4p as=0.4p pd=2.6u ps=2.6u m=1
X33 xpor__NDL xpor__NDL VSS VSS nfet_03v3 L=10u W=2u nf=1 ad=1.6p as=1.6p pd=5.6u ps=5.6u m=1
X34 xpor__NDGN xpor__NDL VSS VSS nfet_03v3 L=10u W=10u nf=1 ad=8p as=8p pd=21.6u ps=21.6u m=1
X35 xpor__NDG POR_RAW xpor__NDGN VSS nfet_03v3 L=0.5u W=1u nf=1 ad=0.8p as=0.8p pd=3.6u ps=3.6u m=1
X36 xpor__PGDG xpor__NDG VSS VSS nfet_03v3 L=0.5u W=2u nf=1 ad=1.6p as=1.6p pd=5.6u ps=5.6u m=1
X37 xpor__PGDGB xpor__PGDG VSS VSS nfet_03v3 L=2u W=0.5u nf=1 ad=0.4p as=0.4p pd=2.6u ps=2.6u m=1
X38 xpor__TIM xpor__PGDGB VSS VSS nfet_03v3 L=1u W=1u nf=1 ad=0.8p as=0.8p pd=3.6u ps=3.6u m=1
X39 xpor__ND1 xpor__NDL VSS VSS nfet_03v3 L=10u W=0.5u nf=1 ad=0.4p as=0.4p pd=2.6u ps=2.6u m=1
X40 xpor__TRIP xpor__ND1 VSS VSS nfet_03v3 L=1u W=1u nf=1 ad=0.8p as=0.8p pd=3.6u ps=3.6u m=1
X41 xpor__ND1 RESETn VSS VSS nfet_03v3 L=1u W=1u nf=1 ad=0.8p as=0.8p pd=3.6u ps=3.6u m=1
X42 xpor__RSTB xpor__TRIP xpor__NNAND VSS nfet_03v3 L=0.5u W=2u nf=1 ad=1.6p as=1.6p pd=5.6u ps=5.6u m=1
X43 xpor__NNAND xpor__PGDG VSS VSS nfet_03v3 L=0.5u W=2u nf=1 ad=1.6p as=1.6p pd=5.6u ps=5.6u m=1
X44 RESETn xpor__RSTB VSS VSS nfet_03v3 L=0.5u W=10u nf=1 ad=8p as=8p pd=21.6u ps=21.6u m=1
X45 VSS VSS VSS VSS nfet_03v3 L=8u W=4u nf=1 ad=3.2p as=3.2p pd=9.6u ps=9.6u m=1
X46 xtemp__N1 xtemp__N1 VSS VSS nfet_03v3 L=8u W=4u nf=1 ad=3.2p as=3.2p pd=9.6u ps=9.6u m=1
X47 xtemp__N2 xtemp__N1 VSS VSS nfet_03v3 L=8u W=4u nf=1 ad=3.2p as=3.2p pd=9.6u ps=9.6u m=1
X48 xtemp__N2 xtemp__N1 VSS VSS nfet_03v3 L=8u W=4u nf=1 ad=3.2p as=3.2p pd=9.6u ps=9.6u m=1
X49 xtemp__N1 xtemp__N1 VSS VSS nfet_03v3 L=8u W=4u nf=1 ad=3.2p as=3.2p pd=9.6u ps=9.6u m=1
X50 VSS VSS VSS VSS nfet_03v3 L=8u W=4u nf=1 ad=3.2p as=3.2p pd=9.6u ps=9.6u m=1
X51 xtemp__PG xtemp__N2 VSS VSS nfet_03v3 L=8u W=8u nf=1 ad=6.4p as=6.4p pd=17.6u ps=17.6u m=1
X52 IBIAS xtemp__NBG VSS VSS nfet_03v3 L=2u W=4u nf=1 ad=3.2p as=3.2p pd=9.6u ps=9.6u m=1
X53 IBIAS RESETn xtemp__NBG VSS nfet_03v3 L=0.5u W=2u nf=1 ad=1.6p as=1.6p pd=5.6u ps=5.6u m=1
X54 xtemp__NBG xtemp__ENB VSS VSS nfet_03v3 L=0.5u W=2u nf=1 ad=1.6p as=1.6p pd=5.6u ps=5.6u m=1
X55 xtemp__PB xtemp__NBG VSS VSS nfet_03v3 L=2u W=4u nf=1 ad=3.2p as=3.2p pd=9.6u ps=9.6u m=1
X56 xtemp__PCAS xtemp__NBG VSS VSS nfet_03v3 L=2u W=4u nf=1 ad=3.2p as=3.2p pd=9.6u ps=9.6u m=1
X57 xtemp__ENB RESETn VSS VSS nfet_03v3 L=0.5u W=1u nf=1 ad=0.8p as=0.8p pd=3.6u ps=3.6u m=1
X58 xtemp__ND xtemp__NR VSS VSS nfet_03v3 L=2u W=2u nf=1 ad=1.6p as=1.6p pd=5.6u ps=5.6u m=1
X59 xtemp__PG xtemp__ND VSS VSS nfet_03v3 L=1u W=4u nf=1 ad=3.2p as=3.2p pd=9.6u ps=9.6u m=1
X60 xtemp__NR xtemp__NR VSS VSS nfet_03v3 L=2u W=2u nf=1 ad=1.6p as=1.6p pd=5.6u ps=5.6u m=1
X61 xtemp__ND xtemp__ENB VSS VSS nfet_03v3 L=0.5u W=2u nf=1 ad=1.6p as=1.6p pd=5.6u ps=5.6u m=1
X62 PTAT xtemp__ENB VSS VSS nfet_03v3 L=1u W=1u nf=1 ad=0.8p as=0.8p pd=3.6u ps=3.6u m=1
X63 CTAT xtemp__ENB VSS VSS nfet_03v3 L=1u W=1u nf=1 ad=0.8p as=0.8p pd=3.6u ps=3.6u m=1
X64 xtemp__N2 xtemp__ENB VSS VSS nfet_03v3 L=1u W=2u nf=1 ad=1.6p as=1.6p pd=5.6u ps=5.6u m=1
X65 xtemp__NT xtemp__ENB VSS VSS nfet_03v3 L=1u W=2u nf=1 ad=1.6p as=1.6p pd=5.6u ps=5.6u m=1
X66 xtemp__T5 VDD xtemp__T4 VSS nfet_03v3 L=0.5u W=32u nf=1 ad=25.6p as=25.6p pd=65.6u ps=65.6u m=1
X67 xtemp__T3 VSS xtemp__T2 VSS nfet_03v3 L=0.5u W=32u nf=1 ad=25.6p as=25.6p pd=65.6u ps=65.6u m=1
X68 xtemp__T1 VSS xtemp__T0 VSS nfet_03v3 L=0.5u W=32u nf=1 ad=25.6p as=25.6p pd=65.6u ps=65.6u m=1
X69 xtemp__T0 VSS VSS VSS nfet_03v3 L=0.5u W=32u nf=1 ad=25.6p as=25.6p pd=65.6u ps=65.6u m=1
X70 xtemp__T2 VSS xtemp__T1 VSS nfet_03v3 L=0.5u W=32u nf=1 ad=25.6p as=25.6p pd=65.6u ps=65.6u m=1
X71 xtemp__T4 VSS xtemp__T3 VSS nfet_03v3 L=0.5u W=32u nf=1 ad=25.6p as=25.6p pd=65.6u ps=65.6u m=1
X72 xbias__NA xbias__PG VDD VDD pfet_03v3 L=4u W=8u nf=1 ad=6.4p as=6.4p pd=17.6u ps=17.6u m=1
X73 xbias__NBTOP xbias__PG VDD VDD pfet_03v3 L=4u W=8u nf=1 ad=6.4p as=6.4p pd=17.6u ps=17.6u m=1
X74 VREF xbias__PG VDD VDD pfet_03v3 L=4u W=8u nf=1 ad=6.4p as=6.4p pd=17.6u ps=17.6u m=1
X75 xbias__NBG xbias__PG VDD VDD pfet_03v3 L=4u W=2u nf=1 ad=1.6p as=1.6p pd=5.6u ps=5.6u m=1
X76 xbias__PB xbias__PB VDD VDD pfet_03v3 L=4u W=2u nf=1 ad=1.6p as=1.6p pd=5.6u ps=5.6u m=1
X77 IBIAS xbias__PB VDD VDD pfet_03v3 L=4u W=40u nf=1 ad=32p as=32p pd=81.6u ps=81.6u m=1
X78 xbias__NT xbias__PB VDD VDD pfet_03v3 L=4u W=2u nf=1 ad=1.6p as=1.6p pd=5.6u ps=5.6u m=1
X79 xbias__N1 xbias__NA xbias__NT VDD pfet_03v3 L=4u W=16u nf=1 ad=12.8p as=12.8p pd=33.6u ps=33.6u m=1
X80 xbias__N2 xbias__NB xbias__NT VDD pfet_03v3 L=4u W=16u nf=1 ad=12.8p as=12.8p pd=33.6u ps=33.6u m=1
X81 xbias__PG xbias__PB VDD VDD pfet_03v3 L=4u W=2u nf=1 ad=1.6p as=1.6p pd=5.6u ps=5.6u m=1
X82 xbias__NKM xbias__PB VDD VDD pfet_03v3 L=4u W=1u nf=1 ad=0.8p as=0.8p pd=3.6u ps=3.6u m=1
X83 xbias__TOK xbias__PB VDD VDD pfet_03v3 L=4u W=1u nf=1 ad=0.8p as=0.8p pd=3.6u ps=3.6u m=1
X84 xbias__NOKO xbias__NA xbias__TOK VDD pfet_03v3 L=4u W=8u nf=1 ad=6.4p as=6.4p pd=17.6u ps=17.6u m=1
X85 xbias__NOKL xbias__NBTOP xbias__TOK VDD pfet_03v3 L=4u W=8u nf=1 ad=6.4p as=6.4p pd=17.6u ps=17.6u m=1
X86 xbias__NOKX xbias__PB VDD VDD pfet_03v3 L=4u W=1u nf=1 ad=0.8p as=0.8p pd=3.6u ps=3.6u m=1
X87 BIAS_OK xbias__NOKX VDD VDD pfet_03v3 L=4u W=1u nf=1 ad=0.8p as=0.8p pd=3.6u ps=3.6u m=1
X88 xcmp__NA xcmp__NA xcmp__VDDA VDD pfet_03v3 L=1u W=4u nf=1 ad=3.2p as=3.2p pd=9.6u ps=9.6u m=1
X89 xcmp__CMPO xcmp__NA xcmp__VDDA VDD pfet_03v3 L=1u W=4u nf=1 ad=3.2p as=3.2p pd=9.6u ps=9.6u m=1
X90 xcmp__VDDA xcmp__BIAS_OKB VDD VDD pfet_03v3 L=0.5u W=4u nf=1 ad=3.2p as=3.2p pd=9.6u ps=9.6u m=1
X91 xcmp__N1 xcmp__CMPO VDD VDD pfet_03v3 L=0.5u W=2u nf=1 ad=1.6p as=1.6p pd=5.6u ps=5.6u m=1
X92 POR_RAW xcmp__N1 VDD VDD pfet_03v3 L=0.5u W=2u nf=1 ad=1.6p as=1.6p pd=5.6u ps=5.6u m=1
X93 xpor__PDN xpor__PDN VDD VDD pfet_03v3 L=10u W=2u nf=1 ad=1.6p as=1.6p pd=5.6u ps=5.6u m=1
X94 xpor__NDL xpor__PDN VDD VDD pfet_03v3 L=10u W=2u nf=1 ad=1.6p as=1.6p pd=5.6u ps=5.6u m=1
X95 xpor__NDGP xpor__PDN VDD VDD pfet_03v3 L=10u W=10u nf=1 ad=8p as=8p pd=21.6u ps=21.6u m=1
X96 xpor__NTS xpor__PDN VDD VDD pfet_03v3 L=10u W=0.5u nf=1 ad=0.4p as=0.4p pd=2.6u ps=2.6u m=1
X97 xpor__TRIP xpor__PDN VDD VDD pfet_03v3 L=10u W=0.5u nf=1 ad=0.4p as=0.4p pd=2.6u ps=2.6u m=1
X98 xpor__NDG POR_RAW xpor__NDGP VDD pfet_03v3 L=0.5u W=1u nf=1 ad=0.8p as=0.8p pd=3.6u ps=3.6u m=1
X99 xpor__PGDG xpor__NDG VDD VDD pfet_03v3 L=2u W=0.5u nf=1 ad=0.4p as=0.4p pd=2.6u ps=2.6u m=1
X100 xpor__PGDGB xpor__PGDG VDD VDD pfet_03v3 L=0.5u W=2u nf=1 ad=1.6p as=1.6p pd=5.6u ps=5.6u m=1
X101 xpor__TIM xpor__PGDGB xpor__NTS VDD pfet_03v3 L=1u W=2u nf=1 ad=1.6p as=1.6p pd=5.6u ps=5.6u m=1
X102 xpor__ND1 xpor__TIM VDD VDD pfet_03v3 L=1u W=2u nf=1 ad=1.6p as=1.6p pd=5.6u ps=5.6u m=1
X103 xpor__RSTB xpor__TRIP VDD VDD pfet_03v3 L=0.5u W=4u nf=1 ad=3.2p as=3.2p pd=9.6u ps=9.6u m=1
X104 xpor__RSTB xpor__PGDG VDD VDD pfet_03v3 L=0.5u W=4u nf=1 ad=3.2p as=3.2p pd=9.6u ps=9.6u m=1
X105 xpor__RSTB RESETn VDD VDD pfet_03v3 L=10u W=0.5u nf=1 ad=0.4p as=0.4p pd=2.6u ps=2.6u m=1
X106 RESETn xpor__RSTB VDD VDD pfet_03v3 L=1u W=1u nf=1 ad=0.8p as=0.8p pd=3.6u ps=3.6u m=1
X107 xtemp__NT xtemp__NT xtemp__NT xtemp__NT pfet_03v3 L=4u W=16u nf=1 ad=12.8p as=12.8p pd=33.6u ps=33.6u m=1
X108 xtemp__N1 xtemp__NA xtemp__NT xtemp__NT pfet_03v3 L=4u W=16u nf=1 ad=12.8p as=12.8p pd=33.6u ps=33.6u m=1
X109 xtemp__N2 xtemp__NB xtemp__NT xtemp__NT pfet_03v3 L=4u W=16u nf=1 ad=12.8p as=12.8p pd=33.6u ps=33.6u m=1
X110 xtemp__N2 xtemp__NB xtemp__NT xtemp__NT pfet_03v3 L=4u W=16u nf=1 ad=12.8p as=12.8p pd=33.6u ps=33.6u m=1
X111 xtemp__N1 xtemp__NA xtemp__NT xtemp__NT pfet_03v3 L=4u W=16u nf=1 ad=12.8p as=12.8p pd=33.6u ps=33.6u m=1
X112 xtemp__NT xtemp__NT xtemp__NT xtemp__NT pfet_03v3 L=4u W=16u nf=1 ad=12.8p as=12.8p pd=33.6u ps=33.6u m=1
X113 xtemp__NT xtemp__PB VDD VDD pfet_03v3 L=4u W=20u nf=1 ad=16p as=16p pd=41.6u ps=41.6u m=1
X114 VDD VDD VDD VDD pfet_03v3 L=4u W=4u nf=1 ad=3.2p as=3.2p pd=9.6u ps=9.6u m=1
X115 xtemp__M1D xtemp__PG VDD VDD pfet_03v3 L=4u W=4u nf=1 ad=3.2p as=3.2p pd=9.6u ps=9.6u m=1
X116 xtemp__NA xtemp__PCAS xtemp__M1D VDD pfet_03v3 L=1u W=4u nf=1 ad=3.2p as=3.2p pd=9.6u ps=9.6u m=1
X117 xtemp__M2D xtemp__PG VDD VDD pfet_03v3 L=4u W=4u nf=1 ad=3.2p as=3.2p pd=9.6u ps=9.6u m=1
X118 xtemp__NB xtemp__PCAS xtemp__M2D VDD pfet_03v3 L=1u W=4u nf=1 ad=3.2p as=3.2p pd=9.6u ps=9.6u m=1
X119 xtemp__M3D xtemp__PG VDD VDD pfet_03v3 L=4u W=4u nf=1 ad=3.2p as=3.2p pd=9.6u ps=9.6u m=1
X120 PTAT xtemp__PCAS xtemp__M3D VDD pfet_03v3 L=1u W=4u nf=1 ad=3.2p as=3.2p pd=9.6u ps=9.6u m=1
X121 PTAT xtemp__PCAS xtemp__M3D VDD pfet_03v3 L=1u W=4u nf=1 ad=3.2p as=3.2p pd=9.6u ps=9.6u m=1
X122 xtemp__M3D xtemp__PG VDD VDD pfet_03v3 L=4u W=4u nf=1 ad=3.2p as=3.2p pd=9.6u ps=9.6u m=1
X123 xtemp__NB xtemp__PCAS xtemp__M2D VDD pfet_03v3 L=1u W=4u nf=1 ad=3.2p as=3.2p pd=9.6u ps=9.6u m=1
X124 xtemp__M2D xtemp__PG VDD VDD pfet_03v3 L=4u W=4u nf=1 ad=3.2p as=3.2p pd=9.6u ps=9.6u m=1
X125 xtemp__NA xtemp__PCAS xtemp__M1D VDD pfet_03v3 L=1u W=4u nf=1 ad=3.2p as=3.2p pd=9.6u ps=9.6u m=1
X126 xtemp__M1D xtemp__PG VDD VDD pfet_03v3 L=4u W=4u nf=1 ad=3.2p as=3.2p pd=9.6u ps=9.6u m=1
X127 VDD VDD VDD VDD pfet_03v3 L=4u W=4u nf=1 ad=3.2p as=3.2p pd=9.6u ps=9.6u m=1
X128 xtemp__PG xtemp__PB VDD VDD pfet_03v3 L=4u W=10u nf=1 ad=8p as=8p pd=21.6u ps=21.6u m=1
X129 xtemp__PB xtemp__PB VDD VDD pfet_03v3 L=4u W=10u nf=1 ad=8p as=8p pd=21.6u ps=21.6u m=1
X130 xtemp__PCAS xtemp__PCAS VDD VDD pfet_03v3 L=8u W=1u nf=1 ad=0.8p as=0.8p pd=3.6u ps=3.6u m=1
X131 xtemp__ENB RESETn VDD VDD pfet_03v3 L=0.5u W=2u nf=1 ad=1.6p as=1.6p pd=5.6u ps=5.6u m=1
X132 xtemp__ND xtemp__PB VDD VDD pfet_03v3 L=8u W=1u nf=1 ad=0.8p as=0.8p pd=3.6u ps=3.6u m=1
X133 xtemp__NR xtemp__PG VDD VDD pfet_03v3 L=4u W=1u nf=1 ad=0.8p as=0.8p pd=3.6u ps=3.6u m=1
X134 xtemp__PG RESETn VDD VDD pfet_03v3 L=0.5u W=4u nf=1 ad=3.2p as=3.2p pd=9.6u ps=9.6u m=1
X135 xcmp__BIAS_OKB BIAS_OK VDD VDD pfet_03v3 L=0.5u W=2u nf=1 ad=1.6p as=1p pd=5.6u ps=5u m=1
X136 VSS VSS xbias__EC pnp_10p00x10p00
X137 VSS VSS xbias__EC pnp_10p00x10p00
X138 VSS VSS xbias__EC pnp_10p00x10p00
X139 VSS VSS xbias__EC pnp_10p00x10p00
X140 VSS VSS xbias__NA pnp_10p00x10p00
X141 VSS VSS xbias__EC pnp_10p00x10p00
X142 VSS VSS xbias__ER pnp_10p00x10p00
X143 VSS VSS xbias__EC pnp_10p00x10p00
X144 VSS VSS xbias__EC pnp_10p00x10p00
X145 VSS VSS xbias__EC pnp_10p00x10p00
X146 VSS VSS xtemp__NC pnp_10p00x10p00
X147 VSS VSS xtemp__NC pnp_10p00x10p00
X148 VSS VSS xtemp__NC pnp_10p00x10p00
X149 VSS VSS xtemp__NC pnp_10p00x10p00
X150 VSS VSS xtemp__NA pnp_10p00x10p00
X151 VSS VSS xtemp__NC pnp_10p00x10p00
X152 VSS VSS xtemp__NC pnp_10p00x10p00
X153 VSS VSS xtemp__NC pnp_10p00x10p00
X154 VSS VSS xtemp__NC pnp_10p00x10p00
X155 xpor__NDG VSS cap_mim_2f0_m3m4_noshield c_width=11u c_length=11u
X156 xpor__TIM VSS cap_mim_2f0_m3m4_noshield c_width=28u c_length=28u
X157 xpor__TIM VSS cap_mim_2f0_m3m4_noshield c_width=28u c_length=28u
X158 xbias__NOKX VDD cap_mim_2f0_m3m4_noshield c_width=6u c_length=6u
X159 xbias__NZ xbias__PG cap_mim_2f0_m3m4_noshield c_width=20u c_length=20u
X160 xpor__TIM VSS cap_mim_2f0_m3m4_noshield c_width=28u c_length=28u
X161 xpor__TIM VSS cap_mim_2f0_m3m4_noshield c_width=28u c_length=28u
X162 xtemp__NB xtemp__XR1__1 VSS ppolyf_u r_width=2u r_length=59.735u
X163 xtemp__NC xtemp__XR1__1 VSS ppolyf_u r_width=2u r_length=59.735u
X164 xtemp__NA xtemp__XRISO__1 VSS ppolyf_u r_width=2u r_length=55.525u
X165 CTAT xtemp__XRISO__1 VSS ppolyf_u r_width=2u r_length=55.525u
X166 xtemp__NZ xtemp__XRZ__1 VSS ppolyf_u r_width=2u r_length=100u
X167 xtemp__XRZ__2 xtemp__XRZ__1 VSS ppolyf_u r_width=2u r_length=100u
X168 xtemp__XRZ__2 xtemp__XRZ__3 VSS ppolyf_u r_width=2u r_length=100u
X169 xtemp__XRZ__4 xtemp__XRZ__3 VSS ppolyf_u r_width=2u r_length=100u
X170 xtemp__XRZ__4 xtemp__XRZ__5 VSS ppolyf_u r_width=2u r_length=100u
X171 xtemp__XRZ__6 xtemp__XRZ__5 VSS ppolyf_u r_width=2u r_length=100u
X172 xtemp__XRZ__6 xtemp__XRZ__7 VSS ppolyf_u r_width=2u r_length=100u
X173 xtemp__XRZ__8 xtemp__XRZ__7 VSS ppolyf_u r_width=2u r_length=100u
X174 xtemp__XRZ__8 xtemp__XRZ__9 VSS ppolyf_u r_width=2u r_length=100u
X175 xtemp__N2 xtemp__XRZ__9 VSS ppolyf_u r_width=2u r_length=100u
X176 PTAT xtemp__XR2F__1 VSS ppolyf_u r_width=2u r_length=110.525u
X177 xtemp__XR2F__2 xtemp__XR2F__1 VSS ppolyf_u r_width=2u r_length=110.525u
X178 xtemp__XR2F__2 xtemp__XR2F__3 VSS ppolyf_u r_width=2u r_length=110.525u
X179 xtemp__XR2F__4 xtemp__XR2F__3 VSS ppolyf_u r_width=2u r_length=110.525u
X180 xtemp__XR2F__4 xtemp__XR2F__5 VSS ppolyf_u r_width=2u r_length=110.525u
X181 xtemp__XR2F__6 xtemp__XR2F__5 VSS ppolyf_u r_width=2u r_length=110.525u
X182 xtemp__XR2F__6 xtemp__XR2F__7 VSS ppolyf_u r_width=2u r_length=110.525u
X183 xtemp__XR2F__8 xtemp__XR2F__7 VSS ppolyf_u r_width=2u r_length=110.525u
X184 xtemp__XR2F__8 xtemp__XR2F__9 VSS ppolyf_u r_width=2u r_length=110.525u
X185 xtemp__XR2F__10 xtemp__XR2F__9 VSS ppolyf_u r_width=2u r_length=110.525u
X186 xtemp__XR2F__10 xtemp__XR2F__11 VSS ppolyf_u r_width=2u r_length=110.525u
X187 xtemp__XR2F__12 xtemp__XR2F__11 VSS ppolyf_u r_width=2u r_length=110.525u
X188 xtemp__XR2F__12 xtemp__XR2F__13 VSS ppolyf_u r_width=2u r_length=110.525u
X189 xtemp__XR2F__14 xtemp__XR2F__13 VSS ppolyf_u r_width=2u r_length=110.525u
X190 xtemp__XR2F__14 xtemp__XR2F__15 VSS ppolyf_u r_width=2u r_length=110.525u
X191 xtemp__XR2F__16 xtemp__XR2F__15 VSS ppolyf_u r_width=2u r_length=110.525u
X192 xtemp__XR2F__16 xtemp__XR2F__17 VSS ppolyf_u r_width=2u r_length=110.525u
X193 xtemp__XR2F__18 xtemp__XR2F__17 VSS ppolyf_u r_width=2u r_length=110.525u
X194 xtemp__XR2F__18 xtemp__XR2F__19 VSS ppolyf_u r_width=2u r_length=110.525u
X195 xtemp__XR2F__20 xtemp__XR2F__19 VSS ppolyf_u r_width=2u r_length=110.525u
X196 xtemp__XR2F__20 xtemp__XR2F__21 VSS ppolyf_u r_width=2u r_length=110.525u
X197 xtemp__XR2F__22 xtemp__XR2F__21 VSS ppolyf_u r_width=2u r_length=110.525u
X198 xtemp__XR2F__22 xtemp__XR2F__23 VSS ppolyf_u r_width=2u r_length=110.525u
X199 xtemp__T5 xtemp__XR2F__23 VSS ppolyf_u r_width=2u r_length=110.525u
X200 xtemp__T5 xtemp__XR2T5__1 VSS ppolyf_u r_width=2u r_length=114.855u
X201 xtemp__T4 xtemp__XR2T5__1 VSS ppolyf_u r_width=2u r_length=114.855u
X202 xtemp__T4 xtemp__XR2T4__1 VSS ppolyf_u r_width=2u r_length=57.345u
X203 xtemp__T3 xtemp__XR2T4__1 VSS ppolyf_u r_width=2u r_length=57.345u
X204 xtemp__T3 xtemp__XR2T3__1 VSS ppolyf_u r_width=2u r_length=28.59u
X205 xtemp__T2 xtemp__XR2T3__1 VSS ppolyf_u r_width=2u r_length=28.59u
X206 xtemp__T2 xtemp__XR2T2__1 VSS ppolyf_u r_width=2u r_length=14.21u
X207 xtemp__T1 xtemp__XR2T2__1 VSS ppolyf_u r_width=2u r_length=14.21u
X208 xtemp__T1 xtemp__XR2T1__1 VSS ppolyf_u r_width=2u r_length=7.015u
X209 xtemp__T0 xtemp__XR2T1__1 VSS ppolyf_u r_width=2u r_length=7.015u
X210 xtemp__T0 xtemp__XR2T0__1 VSS ppolyf_u r_width=2u r_length=3.425u
X211 VSS xtemp__XR2T0__1 VSS ppolyf_u r_width=2u r_length=3.425u
X212 xcmp__SNS VDD VSS ppolyf_u_3k r_width=2u r_length=7897.44u
X213 xcmp__SNSB xcmp__SNS VSS ppolyf_u_3k r_width=2u r_length=6769.23u
X214 VSS xcmp__SNSB VSS ppolyf_u_3k r_width=2u r_length=775u
X215 VREF xbias__XR2__1 VSS ppolyf_u_3k r_width=2u r_length=256.5u
X216 xbias__XR2__2 xbias__XR2__1 VSS ppolyf_u_3k r_width=2u r_length=256.5u
X217 xbias__XR2__2 xbias__XR2__3 VSS ppolyf_u_3k r_width=2u r_length=256.5u
X218 xbias__XR2__4 xbias__XR2__3 VSS ppolyf_u_3k r_width=2u r_length=256.5u
X219 xbias__XR2__4 xbias__XR2__5 VSS ppolyf_u_3k r_width=2u r_length=256.5u
X220 xbias__XR2__6 xbias__XR2__5 VSS ppolyf_u_3k r_width=2u r_length=256.5u
X221 xbias__XR2__6 xbias__XR2__7 VSS ppolyf_u_3k r_width=2u r_length=256.5u
X222 xbias__XR2__8 xbias__XR2__7 VSS ppolyf_u_3k r_width=2u r_length=256.5u
X223 xbias__XR2__8 xbias__XR2__9 VSS ppolyf_u_3k r_width=2u r_length=256.5u
X224 xbias__XR2__10 xbias__XR2__9 VSS ppolyf_u_3k r_width=2u r_length=256.5u
X225 xbias__XR2__10 xbias__XR2__11 VSS ppolyf_u_3k r_width=2u r_length=256.5u
X226 xbias__XR2__12 xbias__XR2__11 VSS ppolyf_u_3k r_width=2u r_length=256.5u
X227 xbias__XR2__12 xbias__XR2__13 VSS ppolyf_u_3k r_width=2u r_length=256.5u
X228 xbias__XR2__14 xbias__XR2__13 VSS ppolyf_u_3k r_width=2u r_length=256.5u
X229 xbias__XR2__14 xbias__XR2__15 VSS ppolyf_u_3k r_width=2u r_length=256.5u
X230 xbias__ER xbias__XR2__15 VSS ppolyf_u_3k r_width=2u r_length=256.5u
X231 xbias__NZ xbias__XRZ__1 VSS ppolyf_u_3k r_width=2u r_length=254u
X232 xbias__XRZ__2 xbias__XRZ__1 VSS ppolyf_u_3k r_width=2u r_length=254u
X233 xbias__XRZ__2 xbias__XRZ__3 VSS ppolyf_u_3k r_width=2u r_length=254u
X234 xbias__N2 xbias__XRZ__3 VSS ppolyf_u_3k r_width=2u r_length=254u
X235 xbias__NB xbias__XR1__1 VSS ppolyf_u_3k r_width=2u r_length=175u
X236 xbias__EC xbias__XR1__1 VSS ppolyf_u_3k r_width=2u r_length=175u
X237 xbias__NBTOP xbias__XRT__1 VSS ppolyf_u_3k r_width=2u r_length=8.75u
X238 xbias__NB xbias__XRT__1 VSS ppolyf_u_3k r_width=2u r_length=8.75u

R_11 xbias__NT xbias__NT__par 4684.5858
C_11 xbias__NT__par VSS 4.9951788e-14
R_116 xtemp__XRZ__2 xtemp__XRZ__2__par 50.5749
C_116 xtemp__XRZ__2__par VSS 1.599507e-15
R_117 xtemp__XRZ__4 xtemp__XRZ__4__par 50.5749
C_117 xtemp__XRZ__4__par VSS 1.599507e-15
R_118 xtemp__XRZ__6 xtemp__XRZ__6__par 50.5749
C_118 xtemp__XRZ__6__par VSS 1.599507e-15
R_119 xtemp__XRZ__8 xtemp__XRZ__8__par 50.5749
C_119 xtemp__XRZ__8__par VSS 1.599507e-15
R_12 xbias__N1 xbias__N1__par 4967.8583
C_12 xbias__N1__par VSS 5.978126e-14
R_120 xtemp__XR2F__2 xtemp__XR2F__2__par 50.5749
C_120 xtemp__XR2F__2__par VSS 1.599507e-15
R_121 xtemp__XR2F__4 xtemp__XR2F__4__par 50.5749
C_121 xtemp__XR2F__4__par VSS 1.599507e-15
R_122 xtemp__XR2F__6 xtemp__XR2F__6__par 50.5749
C_122 xtemp__XR2F__6__par VSS 1.599507e-15
R_123 xtemp__XR2F__8 xtemp__XR2F__8__par 50.5749
C_123 xtemp__XR2F__8__par VSS 1.599507e-15
R_124 xtemp__XR2F__10 xtemp__XR2F__10__par 50.5749
C_124 xtemp__XR2F__10__par VSS 1.599507e-15
R_125 xtemp__XR2F__12 xtemp__XR2F__12__par 50.5749
C_125 xtemp__XR2F__12__par VSS 1.599507e-15
R_126 xtemp__XR2F__14 xtemp__XR2F__14__par 50.5749
C_126 xtemp__XR2F__14__par VSS 1.599507e-15
R_127 xtemp__XR2F__16 xtemp__XR2F__16__par 50.5749
C_127 xtemp__XR2F__16__par VSS 1.599507e-15
R_128 xtemp__XR2F__18 xtemp__XR2F__18__par 50.5749
C_128 xtemp__XR2F__18__par VSS 1.599507e-15
R_129 xtemp__XR2F__20 xtemp__XR2F__20__par 50.5749
C_129 xtemp__XR2F__20__par VSS 1.599507e-15
R_13 xbias__N2 xbias__N2__par 7855.0506
C_13 xbias__N2__par VSS 8.4779094e-14
R_130 xtemp__XR2F__22 xtemp__XR2F__22__par 50.5749
C_130 xtemp__XR2F__22__par VSS 1.599507e-15
R_136 xtemp__XR2T0__1 xtemp__XR2T0__1__par 50.5749
C_136 xtemp__XR2T0__1__par VSS 1.599507e-15
R_137 xtemp__XR2T1__1 xtemp__XR2T1__1__par 50.5749
C_137 xtemp__XR2T1__1__par VSS 1.599507e-15
R_14 xbias__TOK xbias__TOK__par 4690.5254
C_14 xbias__TOK__par VSS 5.2350545e-14
R_142 xtemp__XR2T2__1 xtemp__XR2T2__1__par 50.5749
C_142 xtemp__XR2T2__1__par VSS 1.599507e-15
R_146 xtemp__XR2T3__1 xtemp__XR2T3__1__par 50.5749
C_146 xtemp__XR2T3__1__par VSS 1.599507e-15
R_15 xbias__NOKO xbias__NOKO__par 4792.4183
C_15 xbias__NOKO__par VSS 5.9161863e-14
R_154 xtemp__XRISO__1 xtemp__XRISO__1__par 50.5749
C_154 xtemp__XRISO__1__par VSS 1.599507e-15
R_155 xtemp__XR2T4__1 xtemp__XR2T4__1__par 50.5749
C_155 xtemp__XR2T4__1__par VSS 1.599507e-15
R_156 xtemp__XR1__1 xtemp__XR1__1__par 50.5749
C_156 xtemp__XR1__1__par VSS 1.599507e-15
R_157 xtemp__XRZ__1 xtemp__XRZ__1__par 50.5749
C_157 xtemp__XRZ__1__par VSS 1.599507e-15
R_158 xtemp__XRZ__3 xtemp__XRZ__3__par 50.5749
C_158 xtemp__XRZ__3__par VSS 1.599507e-15
R_159 xtemp__XRZ__5 xtemp__XRZ__5__par 50.5749
C_159 xtemp__XRZ__5__par VSS 1.599507e-15
R_16 xbias__NOKL xbias__NOKL__par 4883.997
C_16 xbias__NOKL__par VSS 6.0794305e-14
R_160 xtemp__XRZ__7 xtemp__XRZ__7__par 50.5749
C_160 xtemp__XRZ__7__par VSS 1.599507e-15
R_161 xtemp__XRZ__9 xtemp__XRZ__9__par 50.5749
C_161 xtemp__XRZ__9__par VSS 1.599507e-15
R_162 xtemp__XR2F__1 xtemp__XR2F__1__par 50.5749
C_162 xtemp__XR2F__1__par VSS 1.599507e-15
R_163 xtemp__XR2F__3 xtemp__XR2F__3__par 50.5749
C_163 xtemp__XR2F__3__par VSS 1.599507e-15
R_164 xtemp__XR2F__5 xtemp__XR2F__5__par 50.5749
C_164 xtemp__XR2F__5__par VSS 1.599507e-15
R_165 xtemp__XR2F__7 xtemp__XR2F__7__par 50.5749
C_165 xtemp__XR2F__7__par VSS 1.599507e-15
R_166 xtemp__XR2F__9 xtemp__XR2F__9__par 50.5749
C_166 xtemp__XR2F__9__par VSS 1.599507e-15
R_167 xtemp__XR2F__11 xtemp__XR2F__11__par 50.5749
C_167 xtemp__XR2F__11__par VSS 1.599507e-15
R_168 xtemp__XR2F__13 xtemp__XR2F__13__par 50.5749
C_168 xtemp__XR2F__13__par VSS 1.599507e-15
R_169 xtemp__XR2F__15 xtemp__XR2F__15__par 50.5749
C_169 xtemp__XR2F__15__par VSS 1.599507e-15
R_17 xbias__NKG xbias__NKG__par 4848.0503
C_17 xbias__NKG__par VSS 5.7785044e-14
R_170 xtemp__XR2F__17 xtemp__XR2F__17__par 50.5749
C_170 xtemp__XR2F__17__par VSS 1.599507e-15
R_171 xtemp__XR2F__19 xtemp__XR2F__19__par 50.5749
C_171 xtemp__XR2F__19__par VSS 1.599507e-15
R_172 xtemp__XR2F__21 xtemp__XR2F__21__par 50.5749
C_172 xtemp__XR2F__21__par VSS 1.599507e-15
R_173 xtemp__XR2F__23 xtemp__XR2F__23__par 50.5749
C_173 xtemp__XR2F__23__par VSS 1.599507e-15
R_174 xtemp__XR2T5__1 xtemp__XR2T5__1__par 50.5749
C_174 xtemp__XR2T5__1__par VSS 1.599507e-15
R_18 xbias__NB xbias__NB__par 7667.0394
C_18 xbias__NB__par VSS 7.6118691e-14
R_19 xcmp__VDDA xcmp__VDDA__par 1263.8244
C_19 xcmp__VDDA__par VSS 1.4679011e-14
R_20 xcmp__NA xcmp__NA__par 1384.846
C_20 xcmp__NA__par VSS 1.5868526e-14
R_21 xcmp__CMPO xcmp__CMPO__par 1382.1249
C_21 xcmp__CMPO__par VSS 1.7766709e-14
R_23 xcmp__N1 xcmp__N1__par 1437.8825
C_23 xcmp__N1__par VSS 1.7866109e-14
R_24 xcmp__TN xcmp__TN__par 1261.1261
C_24 xcmp__TN__par VSS 1.3588667e-14
R_25 xcmp__SNS xcmp__SNS__par 1410.6865
C_25 xcmp__SNS__par VSS 2.5945833e-14
R_26 xcmp__NBG xcmp__NBG__par 1516.9554
C_26 xcmp__NBG__par VSS 2.1326008e-14
R_27 xcmp__SNSB xcmp__SNSB__par 1330.8009
C_27 xcmp__SNSB__par VSS 1.7531363e-14
R_28 xpor__PDN xpor__PDN__par 4872.473
C_28 xpor__PDN__par VSS 5.6524204e-14
R_29 xpor__NDL xpor__NDL__par 4462.4943
C_29 xpor__NDL__par VSS 4.7374149e-14
R_30 xpor__NDGN xpor__NDGN__par 3937.0807
C_30 xpor__NDGN__par VSS 3.4262384e-14
R_31 xpor__PGDG xpor__PGDG__par 4189.4122
C_31 xpor__PGDG__par VSS 4.2342204e-14
R_32 xpor__PGDGB xpor__PGDGB__par 4066.8624
C_32 xpor__PGDGB__par VSS 3.8940744e-14
R_33 xpor__ND1 xpor__ND1__par 4009.3404
C_33 xpor__ND1__par VSS 3.953615e-14
R_34 xpor__NNAND xpor__NNAND__par 3939.9598
C_34 xpor__NNAND__par VSS 3.5425418e-14
R_35 xpor__NDGP xpor__NDGP__par 3936.7209
C_35 xpor__NDGP__par VSS 3.4117005e-14
R_36 xpor__NTS xpor__NTS__par 3938.5202
C_36 xpor__NTS__par VSS 3.4843901e-14
R_37 xpor__RSTB xpor__RSTB__par 4076.1659
C_37 xpor__RSTB__par VSS 4.4250826e-14
R_39 xbias__NKM xbias__NKM__par 4876.8874
C_39 xbias__NKM__par VSS 5.7923066e-14
R_40 xbias__NOKX xbias__NOKX__par 4848.4085
C_40 xbias__NOKX__par VSS 5.9751918e-14
R_41 xbias__KS1 xbias__KS1__par 4818.8511
C_41 xbias__KS1__par VSS 5.4330567e-14
R_42 xbias__KS2 xbias__KS2__par 4819.3911
C_42 xbias__KS2__par VSS 5.4548635e-14
R_43 xbias__KS3 xbias__KS3__par 4819.931
C_43 xbias__KS3__par VSS 5.4766704e-14
R_44 xbias__KS4 xbias__KS4__par 4820.471
C_44 xbias__KS4__par VSS 5.4984773e-14
R_45 xbias__EC xbias__EC__par 2791.7858
C_45 xbias__EC__par VSS 7.4268842e-14
R_46 xbias__NZ xbias__NZ__par 2787.2554
C_46 xbias__NZ__par VSS 2.545538e-14
R_47 xpor__NDG xpor__NDG__par 4070.1194
C_47 xpor__NDG__par VSS 3.8582127e-14
R_48 xpor__TIM xpor__TIM__par 4003.4777
C_48 xpor__TIM__par VSS 3.7210339e-14
R_49 xpor__TRIP xpor__TRIP__par 4060.1793
C_49 xpor__TRIP__par VSS 3.9476253e-14
R_54 xbias__XR2__2 xbias__XR2__2__par 18.25
C_54 xbias__XR2__2__par VSS 1.8067e-15
R_55 xbias__XR2__4 xbias__XR2__4__par 18.25
C_55 xbias__XR2__4__par VSS 1.8067e-15
R_56 xbias__XR2__6 xbias__XR2__6__par 18.25
C_56 xbias__XR2__6__par VSS 1.8067e-15
R_57 xbias__XR2__8 xbias__XR2__8__par 18.25
C_57 xbias__XR2__8__par VSS 1.8067e-15
R_58 xbias__XR2__10 xbias__XR2__10__par 18.25
C_58 xbias__XR2__10__par VSS 1.8067e-15
R_59 xbias__XR2__12 xbias__XR2__12__par 18.25
C_59 xbias__XR2__12__par VSS 1.8067e-15
R_6 xbias__PG xbias__PG__par 5084.0134
C_6 xbias__PG__par VSS 6.8147207e-14
R_60 xbias__XR2__14 xbias__XR2__14__par 18.25
C_60 xbias__XR2__14__par VSS 1.8067e-15
R_61 xbias__XRZ__2 xbias__XRZ__2__par 18.25
C_61 xbias__XRZ__2__par VSS 1.8067e-15
R_62 xbias__XRT__1 xbias__XRT__1__par 18.25
C_62 xbias__XRT__1__par VSS 1.8067e-15
R_63 xbias__NA xbias__NA__par 8008.5898
C_63 xbias__NA__par VSS 8.7590412e-14
R_64 xbias__ER xbias__ER__par 2787.674
C_64 xbias__ER__par VSS 3.3170077e-14
R_7 xbias__NBTOP xbias__NBTOP__par 7796.7657
C_7 xbias__NBTOP__par VSS 7.8325844e-14
R_8 xbias__NBG xbias__NBG__par 4871.7578
C_8 xbias__NBG__par VSS 5.5851412e-14
R_80 xbias__XRZ__1 xbias__XRZ__1__par 18.25
C_80 xbias__XRZ__1__par VSS 1.8067e-15
R_81 xbias__XRZ__3 xbias__XRZ__3__par 18.25
C_81 xbias__XRZ__3__par VSS 1.8067e-15
R_82 xbias__XR1__1 xbias__XR1__1__par 18.25
C_82 xbias__XR1__1__par VSS 1.8067e-15
R_83 xbias__XR2__13 xbias__XR2__13__par 18.25
C_83 xbias__XR2__13__par VSS 1.8067e-15
R_84 xbias__XR2__11 xbias__XR2__11__par 18.25
C_84 xbias__XR2__11__par VSS 1.8067e-15
R_85 xbias__XR2__1 xbias__XR2__1__par 18.25
C_85 xbias__XR2__1__par VSS 1.8067e-15
R_86 xbias__XR2__3 xbias__XR2__3__par 18.25
C_86 xbias__XR2__3__par VSS 1.8067e-15
R_87 xbias__XR2__5 xbias__XR2__5__par 18.25
C_87 xbias__XR2__5__par VSS 1.8067e-15
R_88 xbias__XR2__7 xbias__XR2__7__par 18.25
C_88 xbias__XR2__7__par VSS 1.8067e-15
R_89 xbias__XR2__9 xbias__XR2__9__par 18.25
C_89 xbias__XR2__9__par VSS 1.8067e-15
R_9 xbias__PB xbias__PB__par 5396.0003
C_9 xbias__PB__par VSS 7.9168117e-14
R_90 xbias__XR2__15 xbias__XR2__15__par 18.25
C_90 xbias__XR2__15__par VSS 1.8067e-15
RBIAS_OK BIAS_OK BIAS_OK__par 6145.4389
CBIAS_OK BIAS_OK__par VSS 6.2768673e-14
RBIAS_OKB xcmp__BIAS_OKB xcmp__BIAS_OKB__par 1631.1837
CBIAS_OKB xcmp__BIAS_OKB__par VSS 2.1659338e-14
RCTAT CTAT CTAT__par 508.901
CCTAT CTAT__par VSS 3.2409351e-14
REN_RESETn RESETn RESETn__par 5644.0621
CEN_RESETn RESETn__par VSS 7.8040539e-14
RENB xtemp__ENB xtemp__ENB__par 1722.3174
CENB xtemp__ENB__par VSS 3.6434644e-14
RIBIAS IBIAS IBIAS__par 10641.6413
CIBIAS IBIAS__par VSS 1.22603459e-13
RM1D xtemp__M1D xtemp__M1D__par 1326.5002
CM1D xtemp__M1D__par VSS 2.6584926e-14
RM2D xtemp__M2D xtemp__M2D__par 1250.9542
CM2D xtemp__M2D__par VSS 2.5194004e-14
RM3D xtemp__M3D xtemp__M3D__par 1175.4138
CM3D xtemp__M3D__par VSS 2.3803081e-14
RN1 xtemp__N1 xtemp__N1__par 3916.0744
CN1 xtemp__N1__par VSS 3.9166451e-14
RN2 xtemp__N2 xtemp__N2__par 2349.712
CN2 xtemp__N2__par VSS 5.2203575e-14
RNA xtemp__NA xtemp__NA__par 2133.218
CNA xtemp__NA__par VSS 6.3089263e-14
RNB xtemp__NB xtemp__NB__par 2057.3709
CNB xtemp__NB__par VSS 4.3487422e-14
RNBG xtemp__NBG xtemp__NBG__par 1144.9314
CNBG xtemp__NBG__par VSS 2.6946068e-14
RNC xtemp__NC xtemp__NC__par 65.9407
CNC xtemp__NC__par VSS 8.5417204e-14
RND xtemp__ND xtemp__ND__par 1512.6715
CND xtemp__ND__par VSS 3.4769335e-14
RNR xtemp__NR xtemp__NR__par 1694.9168
CNR xtemp__NR__par VSS 3.5399052e-14
RNT xtemp__NT xtemp__NT__par 5451.5605
CNT xtemp__NT__par VSS 7.8898189e-14
RNZ xtemp__NZ xtemp__NZ__par 105.4542
CNZ xtemp__NZ__par VSS 2.9318592e-14
RPB xtemp__PB xtemp__PB__par 3535.6753
CPB xtemp__PB__par VSS 4.7145745e-14
RPCAS xtemp__PCAS xtemp__PCAS__par 4548.8647
CPCAS xtemp__PCAS__par VSS 5.3738496e-14
RPG xtemp__PG xtemp__PG__par 5100.5412
CPG xtemp__PG__par VSS 6.1711967e-14
RPOR_RAW POR_RAW POR_RAW__par 5322.6333
CPOR_RAW POR_RAW__par VSS 4.7741177e-14
RPTAT PTAT PTAT__par 962.4337
CPTAT PTAT__par VSS 3.9542032e-14
RT0 xtemp__T0 xtemp__T0__par 1253.0071
CT0 xtemp__T0__par VSS 5.5998739e-14
RT1 xtemp__T1 xtemp__T1__par 1214.9021
CT1 xtemp__T1__par VSS 5.5179431e-14
RT2 xtemp__T2 xtemp__T2__par 1176.8024
CT2 xtemp__T2__par VSS 5.4360123e-14
RT3 xtemp__T3 xtemp__T3__par 1138.7083
CT3 xtemp__T3__par VSS 5.3540815e-14
RT4 xtemp__T4 xtemp__T4__par 1100.6204
CT4 xtemp__T4__par VSS 5.2721507e-14
RT5 xtemp__T5 xtemp__T5__par 607.3914
CT5 xtemp__T5__par VSS 4.5515196e-14
RVDD VDD VDD__par 12215.7599
CVDD VDD__par VSS 3.73907065e-13
RVREF VREF VREF__par 9024.0306
CVREF VREF__par VSS 8.5089816e-14
RVSS VSS VSS__par 3387.026
CVSS VSS__par VSS 1.829253353e-12
.ends temp_por_top
