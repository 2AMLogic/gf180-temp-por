* por_output_chain -- klt lvs reference netlist
* generated by layout/lvs_reference.py from design/netlist/por_output_chain.spice
* Do not edit: edit the schematic, re-run design/netlist.py, re-run this.
.SUBCKT por_output_chain IBIAS POR_RAW RESETn VDD VSS
M1 IBIAS IBIAS VSS VSS nfet L=4U W=4U
M2 PDN PDN VDD VDD pfet L=10U W=2U
M3 PDN IBIAS VSS VSS nfet L=25U W=0.5U
M4 NDL NDL VSS VSS nfet L=10U W=2U
M5 NDGN NDL VSS VSS nfet L=10U W=10U
M6 NDG POR_RAW NDGN VSS nfet L=0.5U W=1U
M7 PGDG NDG VSS VSS nfet L=0.5U W=2U
M8 PGDGB PGDG VSS VSS nfet L=2U W=0.5U
M9 TIM PGDGB VSS VSS nfet L=1U W=1U
M10 ND1 NDL VSS VSS nfet L=10U W=0.5U
M11 TRIP ND1 VSS VSS nfet L=1U W=1U
M12 ND1 RESETn VSS VSS nfet L=1U W=1U
M13 RSTB TRIP NNAND VSS nfet L=0.5U W=2U
M14 NNAND PGDG VSS VSS nfet L=0.5U W=2U
M15 RESETn RSTB VSS VSS nfet L=0.5U W=10U
M16 NDL PDN VDD VDD pfet L=10U W=2U
M17 NDGP PDN VDD VDD pfet L=10U W=10U
M18 NTS PDN VDD VDD pfet L=10U W=0.5U
M19 TRIP PDN VDD VDD pfet L=10U W=0.5U
M20 NDG POR_RAW NDGP VDD pfet L=0.5U W=1U
M21 PGDG NDG VDD VDD pfet L=2U W=0.5U
M22 PGDGB PGDG VDD VDD pfet L=0.5U W=2U
M23 TIM PGDGB NTS VDD pfet L=1U W=2U
M24 ND1 TIM VDD VDD pfet L=1U W=2U
M25 RSTB TRIP VDD VDD pfet L=0.5U W=4U
M26 RSTB PGDG VDD VDD pfet L=0.5U W=4U
M27 RSTB RESETn VDD VDD pfet L=10U W=0.5U
M28 RESETn RSTB VDD VDD pfet L=1U W=1U
C29 NDG VSS 2.512752e-13 cap_mim_2f0_m4m5_noshield A=121P P=44U
C30 TIM VSS 1.5868496e-12 cap_mim_2f0_m4m5_noshield A=784P P=112U
C31 TIM VSS 1.5868496e-12 cap_mim_2f0_m4m5_noshield A=784P P=112U
C32 TIM VSS 1.5868496e-12 cap_mim_2f0_m4m5_noshield A=784P P=112U
C33 TIM VSS 1.5868496e-12 cap_mim_2f0_m4m5_noshield A=784P P=112U
.ENDS por_output_chain
