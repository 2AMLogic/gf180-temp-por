* Frozen netlist snapshot for record 20260811-114349-9fcede8
* source     : sim/bias-core-designer-check/testbench/tb_bias_core.spice
* sha256     : 906de9cae62e8d5cb3970373bbd51141c447659526b74d85e0f94ad939613f28
* This is a verbatim copy taken at record time. Do not edit.
* tb_bias_core -- GENERATED by sim/build_tb.py
* Do not edit. Sources:
*   sim/bias-core-designer-check/testbench/stimulus.spice
*   design/netlist/bias_core.spice  (sha256 87b6f9437f43932e965022b3effd38d18cc21aa7bcf675fb1d383b6e91d8baeb)
* Regenerate with:
*   python3 sim/build_tb.py

* bias-core-designer-check -- stimulus half of the testbench fragment.
*
* The other half is a verbatim copy of design/netlist/bias_core.spice,
* appended by sim/build_tb.py to produce tb_bias_core.spice. Edit THIS file
* (or the schematic), never the generated fragment.
*
* Netlist FRAGMENT: no .include / .lib / .temp / .control / .end -- the
* harness owns those. Parameters it supplies: vdd_val, vdd_nom, temp_c.
*
* bias_core has NO enable pin and no off state, so there is only one Iq
* state to measure: the always-on one. That is exactly the state
* spec/target-spec.md SS5 rule 1 quotes por-iq in, which is why this record
* can charge the whole of branch 1's supply current to that row without any
* apportionment argument.
*
* FIVE branches, all in one transient so every number below comes from one
* corner point:
*
*   1. xst   STATIC DUT at this point's vdd_val, DC supply. Supplies the
*            settled numbers (VREF, IBIAS, Iq, BIAS_OK) AND the degenerate-
*            state check: this deck does NOT use `uic`, so ngspice solves a
*            real operating point at t=0 with this branch already at full
*            rail. `vref_op_v` samples that solution. A bandgap loop has a
*            zero-current solution as well as its intended one, and the DC
*            solver is free to land on it -- design/temp_core.md records
*            exactly that happening to #9's first revision. If it lands
*            there here, vref_op_v reads ~0 and the check fails.
*
*   2. xs    SLOW ramp (0 -> vdd_val in 500 us), then held. Supplies settling
*            time, the core's dropout voltage, and BIAS_OK's assertion point
*            measured against the reference's OWN settled value at the same
*            corner (branch 1's), not against a hardcoded target.
*
*   3. xf    FAST ramp: 0 -> vdd_val in 3.63 us, i.e. exactly 1.0 V/us at
*            the 3.63 V rail -- spec/target-spec.md#por-ramp-rate's ratified
*            FAST LIMIT, not beyond it. This is where a reference that is
*            still settling could let the POR comparator release early, so
*            both ramps carry the release guard and the false-valid integral
*            below.
*
*   4. xb    SHALLOW BROWNOUT: settle, dip to 0.5 V (rail low but nodes
*            still charged -- the classic latch trap), recover, hold.
*            `bo_shallow_ppm` compares the reference before and after.
*
*   5. xd    DEEP BROWNOUT: settle, collapse to 0 V, recover, hold.
*            `bo_deep_ppm` compares the reference before and after;
*            `ok_bo_dip_mv` / `t_bo_recover_us` / `ok_bo_end_droop_mv` are
*            taken here.
*
* WHY 4 AND 5 ARE SEPARATE DUTS, AND WHY THE TRANSIENT RUNS TO 30 ms
* (issue #185). Both were one serialized branch on a 2 ms transient until
* the post-layout re-run (#84) made the cost of that visible: this cell's
* own documented STARVED-LOOP WINDOW (design/bias_core.md) is longer than
* 2 ms at many corners once real interconnect parasitics are in the netlist,
* so the 2 ms deck was shorter than the phenomenon it was measuring. Three
* separate symptoms, all one cause:
*
*   - `t_bo_recover_us` read NEGATIVE at 34 of 81 points in record
*     20260811-063744-5ff219c -- a recovery before the rail returned, which
*     is impossible. `when v(bias_okb)=1.4 rise=last` had no genuine
*     post-collapse crossing inside 2 ms to find, so it returned the
*     capacitive blip BIAS_OK makes while the rail's own 10 us return ramp
*     drags the high-impedance node through 1.4 V.
*   - `t_false_ok_fast_us` and `t_false_ok_brownout_us` SATURATED against
*     the integration window (14 points each within 25 us of the ceiling),
*     understating the false-valid time by up to an order of magnitude.
*     design/bias_core.md's own text already recorded a 4.4 ms starved
*     window at sf/-40 C, i.e. longer than the deck that was measuring it.
*   - `bo_shallow_ppm`, `bo_deep_ppm` and `ok_bo_end_droop_mv` are fixed
*     wall-clock samples that consequently landed INSIDE the starved window
*     rather than after it, so they reported the starved loop instead of the
*     property in their own descriptions. At tt/27 C/3.63 V the 1.95 ms
*     `ok_bo_end` sample landed in the 113 us notch during which BIAS_OK is
*     CORRECTLY low, mid-recovery -- reading a 3630 mV droop off a cell that
*     recovers 49 us later.
*
* Splitting the two events onto their own DUTs is not only about run time
* (5 DUTs x 30 ms costs less than 4 DUTs x 50 ms would). It removes a real
* methodological flaw: serialized, the 0.5 V dip parks the loop at the slow
* corners and it is STILL parked when the deep collapse arrives 400 us
* later, so `bo_deep_ppm` was never measuring recovery from a collapse of a
* settled cell. Each branch now sees its event from the settled state and
* gets its own recovery window.
*
* 30 ms is a MEASURED choice, and it is deliberately not large enough to
* make every corner pass. ../control/run_starved_window.py takes the same
* brownout event out to 120 ms at the corners this deck does not clear and
* shows the reference DOES come back there -- slowly, not never -- so a
* corner whose `bo_*_ppm` still fails at 29.9 ms is reporting a recovery
* that is still in progress, which is the honest answer. Lengthening the
* deck until the grid goes green would be hiding exactly the number
* `t_false_ok_brownout_us` and `t_bo_recover_us` exist to report.
*
* THE FALSE-VALID INTEGRAL (Bfos / Bfof) is the correctness statement about
* BIAS_OK: it is 1 whenever BIAS_OK is a valid high AND the reference is more
* than 100 mV BELOW its settled value at this corner, and the record
* integrates it into a time. Zero means "BIAS_OK was never a valid high on a
* reference that was low enough to matter".
*
* It is deliberately ONE-SIDED, matching the settle detector it is testing.
* A reference that is HIGH raises por_comparator's threshold and therefore
* delays release, which spec/target-spec.md#por-reset-pulse explicitly does
* not bound ("no maximum specified in wave 1"). A reference that is LOW
* lowers the threshold and releases early, below the ratified
* spec/target-spec.md#por-vth-rise minimum. Only the second is a correctness
* failure, and only the second is counted here.
*
* THE RELEASE GUARD (Brels / Brelf) is the load-bearing measurement for
* BIAS_OK. por_comparator releases when its divided rail reaches VREF, i.e.
* when VDD >= VREF * (RTOP+RBOT)/RBOT = 2.16667*VREF
* (design/por_comparator.md, "Device sizing"), and that decision only becomes
* authoritative once BIAS_OK is high (DR-005 startup ordering, step 4). The
* B-source therefore reports -1 whenever BIAS_OK is not a valid high and
* (VDD - 2.16667*VREF) when it is; its first zero crossing is the rail at
* which the assembled block WOULD release. Checking that against
* spec/target-spec.md#por-vth-rise's 2.47 V minimum is a direct test of
* "BIAS_OK never goes valid early enough to matter", which is stronger than
* timing BIAS_OK against VREF in isolation.
*
* The 2.16667 ratio is por_comparator's committed divider ratio, quoted here
* as a constant rather than simulated: this record is about bias_core, and
* wiring the real comparator in would make it a top-level record instead
* (that is #14's job). sim/bias-core-ibias-sharing/ is the one place this
* issue does instantiate the neighbours, and only to check the shared IBIAS
* net, not thresholds.

* ---- 1. static DUT, full rail, IBIAS metered -------------------------
* The IBIAS load is a diode-connected nfet_03v3 2u/2u -- por_comparator's
* own XMBD (design/por_comparator.md, "Enable path"), so the pin sees the
* load it will actually drive in the reset-asserted state.
vsupst vddst 0 dc {vdd_val}
vibst  nibst ibiasst dc 0
xst    vddst 0 nibst vrefst bias_okst bias_core
xmldst ibiasst ibiasst 0 0 nfet_03v3 L=2u W=2u nf=1 m=1

* ---- 2. slow ramp ----------------------------------------------------
vsups vdds 0 PWL(0 0 500u {vdd_val} 30m {vdd_val})
vibs  nibs ibiass dc 0
xs    vdds 0 nibs vrefs bias_oks bias_core
xmlds ibiass ibiass 0 0 nfet_03v3 L=2u W=2u nf=1 m=1
Bes  es  0 v = abs(v(vrefs) - v(vrefst))
Brels rels 0 v = (v(bias_oks) > 0.5*v(vdds)) ? (v(vdds) - 2.16667*v(vrefs)) : -1
Brr9s rr9s 0 v = v(vrefs) - 0.9*v(vrefst)
Bfos fos 0 v = ((v(bias_oks) > 0.5*v(vdds)) ? 1 : 0) * ((v(vrefst)-v(vrefs) > 0.1) ? 1 : 0)

* ---- 3. fast ramp ----------------------------------------------------
vsupf vddf 0 PWL(0 0 3.63u {vdd_val} 30m {vdd_val})
vibf  nibf ibiasf dc 0
xf    vddf 0 nibf vreff bias_okf bias_core
xmldf ibiasf ibiasf 0 0 nfet_03v3 L=2u W=2u nf=1 m=1
Bef  ef  0 v = abs(v(vreff) - v(vrefst))
Brelf relf 0 v = (v(bias_okf) > 0.5*v(vddf)) ? (v(vddf) - 2.16667*v(vreff)) : -1
Bfof fof 0 v = ((v(bias_okf) > 0.5*v(vddf)) ? 1 : 0) * ((v(vrefst)-v(vreff) > 0.1) ? 1 : 0)

* ---- 4. shallow brownout: dip to 0.5 V, then a 29.4 ms recovery hold --
* The rail goes below the core's dropout but every internal node keeps its
* charge -- the state a bandgap latches in if it can. Edges are the deck's
* original 10 us (313 mV/us at a 3.63 V rail). That is far outside
* spec/target-spec.md#por-brownout's ratified falling-slew envelope
* (dVDD/dt|fall,max = 3.40 mV/us, DR-011) ON PURPOSE: this branch is the
* hostile probe of the latch question, not a conformance test of that row.
vsupb vddb 0 PWL(0 0 100u {vdd_val} 400u {vdd_val} 410u 0.5 550u 0.5
+ 560u {vdd_val} 30m {vdd_val})
vibb  nibb ibiasb dc 0
xb    vddb 0 nibb vrefb bias_okb bias_core
xmldb ibiasb ibiasb 0 0 nfet_03v3 L=2u W=2u nf=1 m=1
Bfob fob 0 v = ((v(bias_okb) > 0.5*v(vddb)) ? 1 : 0) * ((v(vrefst)-v(vrefb) > 0.1) ? 1 : 0)

* ---- 5. deep brownout: full collapse to 0 V, then a 28.8 ms hold -----
* Same event on a cell that was settled when it arrived, rather than on one
* the shallow dip had already parked (see the header note on why these are
* two DUTs). `ok_bo_dip` samples this branch mid-collapse, `t_bo_rec` times
* BIAS_OK's return, and `bo_deep_ppm` compares VREF at 940 us (settled,
* pre-collapse) against VREF at 29.9 ms.
vsupd vddd 0 PWL(0 0 100u {vdd_val} 950u {vdd_val} 960u 0 1100u 0
+ 1110u {vdd_val} 30m {vdd_val})
vibd  nibd ibiasd dc 0
xd    vddd 0 nibd vrefd bias_okd bias_core
xmldd ibiasd ibiasd 0 0 nfet_03v3 L=2u W=2u nf=1 m=1
Bfod fod 0 v = ((v(bias_okd) > 0.5*v(vddd)) ? 1 : 0) * ((v(vrefst)-v(vrefd) > 0.1) ? 1 : 0)

* bias_core -- generated by design/netlist.py from design/bias_core.sch
* Do not edit: edit the schematic and re-run the export.
** sch_path: design/bias_core.sch
.subckt bias_core VDD VSS IBIAS VREF BIAS_OK
*.PININFO VDD:B VSS:B IBIAS:O VREF:O BIAS_OK:O
XMP1 NA PG VDD VDD pfet_03v3 L=4u W=8u nf=1 ad='int((nf+1)/2) * W/nf * 0.18u' as='int((nf+2)/2) * W/nf * 0.18u' pd='2*int((nf+1)/2) * (W/nf + 0.18u)'
+ ps='2*int((nf+2)/2) * (W/nf + 0.18u)' nrd='0.18u / W' nrs='0.18u / W' sa=0 sb=0 sd=0 m=1
XMP2 NBTOP PG VDD VDD pfet_03v3 L=4u W=8u nf=1 ad='int((nf+1)/2) * W/nf * 0.18u' as='int((nf+2)/2) * W/nf * 0.18u' pd='2*int((nf+1)/2) * (W/nf + 0.18u)'
+ ps='2*int((nf+2)/2) * (W/nf + 0.18u)' nrd='0.18u / W' nrs='0.18u / W' sa=0 sb=0 sd=0 m=1
XMP3 VREF PG VDD VDD pfet_03v3 L=4u W=8u nf=1 ad='int((nf+1)/2) * W/nf * 0.18u' as='int((nf+2)/2) * W/nf * 0.18u' pd='2*int((nf+1)/2) * (W/nf + 0.18u)'
+ ps='2*int((nf+2)/2) * (W/nf + 0.18u)' nrd='0.18u / W' nrs='0.18u / W' sa=0 sb=0 sd=0 m=1
XMPBN NBG PG VDD VDD pfet_03v3 L=4u W=2u nf=1 ad='int((nf+1)/2) * W/nf * 0.18u' as='int((nf+2)/2) * W/nf * 0.18u' pd='2*int((nf+1)/2) * (W/nf + 0.18u)'
+ ps='2*int((nf+2)/2) * (W/nf + 0.18u)' nrd='0.18u / W' nrs='0.18u / W' sa=0 sb=0 sd=0 m=1
XQ1 VSS VSS NA pnp_10p00x10p00 m=1
XRT NBTOP NB VSS ppolyf_u_3k r_width=2u r_length=17.5u m=1
XR1 NB EC VSS ppolyf_u_3k r_width=2u r_length=350.0u m=1
XQ8A VSS VSS EC pnp_10p00x10p00 m=1
XQ8B VSS VSS EC pnp_10p00x10p00 m=1
XQ8C VSS VSS EC pnp_10p00x10p00 m=1
XQ8D VSS VSS EC pnp_10p00x10p00 m=1
XQ8E VSS VSS EC pnp_10p00x10p00 m=1
XQ8F VSS VSS EC pnp_10p00x10p00 m=1
XQ8G VSS VSS EC pnp_10p00x10p00 m=1
XQ8H VSS VSS EC pnp_10p00x10p00 m=1
XR2 VREF ER VSS ppolyf_u_3k r_width=2u r_length=4104.0u m=1
XQR VSS VSS ER pnp_10p00x10p00 m=1
XMBN NBG NBG VSS VSS nfet_03v3 L=4u W=2u nf=1 ad='int((nf+1)/2) * W/nf * 0.18u' as='int((nf+2)/2) * W/nf * 0.18u' pd='2*int((nf+1)/2) * (W/nf + 0.18u)'
+ ps='2*int((nf+2)/2) * (W/nf + 0.18u)' nrd='0.18u / W' nrs='0.18u / W' sa=0 sb=0 sd=0 m=1
XMBN2 PB NBG VSS VSS nfet_03v3 L=4u W=2u nf=1 ad='int((nf+1)/2) * W/nf * 0.18u' as='int((nf+2)/2) * W/nf * 0.18u' pd='2*int((nf+1)/2) * (W/nf + 0.18u)'
+ ps='2*int((nf+2)/2) * (W/nf + 0.18u)' nrd='0.18u / W' nrs='0.18u / W' sa=0 sb=0 sd=0 m=1
XMBP PB PB VDD VDD pfet_03v3 L=4u W=2u nf=1 ad='int((nf+1)/2) * W/nf * 0.18u' as='int((nf+2)/2) * W/nf * 0.18u' pd='2*int((nf+1)/2) * (W/nf + 0.18u)'
+ ps='2*int((nf+2)/2) * (W/nf + 0.18u)' nrd='0.18u / W' nrs='0.18u / W' sa=0 sb=0 sd=0 m=1
XMPIB IBIAS PB VDD VDD pfet_03v3 L=4u W=40u nf=1 ad='int((nf+1)/2) * W/nf * 0.18u' as='int((nf+2)/2) * W/nf * 0.18u' pd='2*int((nf+1)/2) * (W/nf + 0.18u)'
+ ps='2*int((nf+2)/2) * (W/nf + 0.18u)' nrd='0.18u / W' nrs='0.18u / W' sa=0 sb=0 sd=0 m=1
XMPT NT PB VDD VDD pfet_03v3 L=4u W=2u nf=1 ad='int((nf+1)/2) * W/nf * 0.18u' as='int((nf+2)/2) * W/nf * 0.18u' pd='2*int((nf+1)/2) * (W/nf + 0.18u)'
+ ps='2*int((nf+2)/2) * (W/nf + 0.18u)' nrd='0.18u / W' nrs='0.18u / W' sa=0 sb=0 sd=0 m=1
XMI1 N1 NA NT VDD pfet_03v3 L=4u W=16u nf=1 ad='int((nf+1)/2) * W/nf * 0.18u' as='int((nf+2)/2) * W/nf * 0.18u' pd='2*int((nf+1)/2) * (W/nf + 0.18u)'
+ ps='2*int((nf+2)/2) * (W/nf + 0.18u)' nrd='0.18u / W' nrs='0.18u / W' sa=0 sb=0 sd=0 m=1
XMI2 N2 NB NT VDD pfet_03v3 L=4u W=16u nf=1 ad='int((nf+1)/2) * W/nf * 0.18u' as='int((nf+2)/2) * W/nf * 0.18u' pd='2*int((nf+1)/2) * (W/nf + 0.18u)'
+ ps='2*int((nf+2)/2) * (W/nf + 0.18u)' nrd='0.18u / W' nrs='0.18u / W' sa=0 sb=0 sd=0 m=1
XML1 N1 N1 VSS VSS nfet_03v3 L=8u W=4u nf=1 ad='int((nf+1)/2) * W/nf * 0.18u' as='int((nf+2)/2) * W/nf * 0.18u' pd='2*int((nf+1)/2) * (W/nf + 0.18u)'
+ ps='2*int((nf+2)/2) * (W/nf + 0.18u)' nrd='0.18u / W' nrs='0.18u / W' sa=0 sb=0 sd=0 m=1
XML2 N2 N1 VSS VSS nfet_03v3 L=8u W=4u nf=1 ad='int((nf+1)/2) * W/nf * 0.18u' as='int((nf+2)/2) * W/nf * 0.18u' pd='2*int((nf+1)/2) * (W/nf + 0.18u)'
+ ps='2*int((nf+2)/2) * (W/nf + 0.18u)' nrd='0.18u / W' nrs='0.18u / W' sa=0 sb=0 sd=0 m=1
XMS2N PG N2 VSS VSS nfet_03v3 L=8u W=8u nf=1 ad='int((nf+1)/2) * W/nf * 0.18u' as='int((nf+2)/2) * W/nf * 0.18u' pd='2*int((nf+1)/2) * (W/nf + 0.18u)'
+ ps='2*int((nf+2)/2) * (W/nf + 0.18u)' nrd='0.18u / W' nrs='0.18u / W' sa=0 sb=0 sd=0 m=1
XMS2P PG PB VDD VDD pfet_03v3 L=4u W=2u nf=1 ad='int((nf+1)/2) * W/nf * 0.18u' as='int((nf+2)/2) * W/nf * 0.18u' pd='2*int((nf+1)/2) * (W/nf + 0.18u)'
+ ps='2*int((nf+2)/2) * (W/nf + 0.18u)' nrd='0.18u / W' nrs='0.18u / W' sa=0 sb=0 sd=0 m=1
XCC PG NZ cap_mim_2f0_m3m4_noshield c_width=20u c_length=20u m=1
XRZ NZ N2 VSS ppolyf_u_3k r_width=2u r_length=1016.0u m=1
XKS0 VDD VDD KS1 VSS nfet_03v3 L=8u W=1u nf=1 ad='int((nf+1)/2) * W/nf * 0.18u' as='int((nf+2)/2) * W/nf * 0.18u' pd='2*int((nf+1)/2) * (W/nf + 0.18u)'
+ ps='2*int((nf+2)/2) * (W/nf + 0.18u)' nrd='0.18u / W' nrs='0.18u / W' sa=0 sb=0 sd=0 m=1
XKS1 KS1 KS1 KS2 VSS nfet_03v3 L=8u W=1u nf=1 ad='int((nf+1)/2) * W/nf * 0.18u' as='int((nf+2)/2) * W/nf * 0.18u' pd='2*int((nf+1)/2) * (W/nf + 0.18u)'
+ ps='2*int((nf+2)/2) * (W/nf + 0.18u)' nrd='0.18u / W' nrs='0.18u / W' sa=0 sb=0 sd=0 m=1
XKS2 KS2 KS2 KS3 VSS nfet_03v3 L=8u W=1u nf=1 ad='int((nf+1)/2) * W/nf * 0.18u' as='int((nf+2)/2) * W/nf * 0.18u' pd='2*int((nf+1)/2) * (W/nf + 0.18u)'
+ ps='2*int((nf+2)/2) * (W/nf + 0.18u)' nrd='0.18u / W' nrs='0.18u / W' sa=0 sb=0 sd=0 m=1
XKS3 KS3 KS3 KS4 VSS nfet_03v3 L=8u W=1u nf=1 ad='int((nf+1)/2) * W/nf * 0.18u' as='int((nf+2)/2) * W/nf * 0.18u' pd='2*int((nf+1)/2) * (W/nf + 0.18u)'
+ ps='2*int((nf+2)/2) * (W/nf + 0.18u)' nrd='0.18u / W' nrs='0.18u / W' sa=0 sb=0 sd=0 m=1
XKS4 KS4 KS4 NKG VSS nfet_03v3 L=8u W=1u nf=1 ad='int((nf+1)/2) * W/nf * 0.18u' as='int((nf+2)/2) * W/nf * 0.18u' pd='2*int((nf+1)/2) * (W/nf + 0.18u)'
+ ps='2*int((nf+2)/2) * (W/nf + 0.18u)' nrd='0.18u / W' nrs='0.18u / W' sa=0 sb=0 sd=0 m=1
XKA NKM PB VDD VDD pfet_03v3 L=4u W=1u nf=1 ad='int((nf+1)/2) * W/nf * 0.18u' as='int((nf+2)/2) * W/nf * 0.18u' pd='2*int((nf+1)/2) * (W/nf + 0.18u)'
+ ps='2*int((nf+2)/2) * (W/nf + 0.18u)' nrd='0.18u / W' nrs='0.18u / W' sa=0 sb=0 sd=0 m=1
XKAN NKM NKM VSS VSS nfet_03v3 L=4u W=2u nf=1 ad='int((nf+1)/2) * W/nf * 0.18u' as='int((nf+2)/2) * W/nf * 0.18u' pd='2*int((nf+1)/2) * (W/nf + 0.18u)'
+ ps='2*int((nf+2)/2) * (W/nf + 0.18u)' nrd='0.18u / W' nrs='0.18u / W' sa=0 sb=0 sd=0 m=1
XKPD NKG NKM VSS VSS nfet_03v3 L=4u W=8u nf=1 ad='int((nf+1)/2) * W/nf * 0.18u' as='int((nf+2)/2) * W/nf * 0.18u' pd='2*int((nf+1)/2) * (W/nf + 0.18u)'
+ ps='2*int((nf+2)/2) * (W/nf + 0.18u)' nrd='0.18u / W' nrs='0.18u / W' sa=0 sb=0 sd=0 m=1
XKICK PG NKG VSS VSS nfet_03v3 L=4u W=1u nf=1 ad='int((nf+1)/2) * W/nf * 0.18u' as='int((nf+2)/2) * W/nf * 0.18u' pd='2*int((nf+1)/2) * (W/nf + 0.18u)'
+ ps='2*int((nf+2)/2) * (W/nf + 0.18u)' nrd='0.18u / W' nrs='0.18u / W' sa=0 sb=0 sd=0 m=1
XMPOK TOK PB VDD VDD pfet_03v3 L=4u W=1u nf=1 ad='int((nf+1)/2) * W/nf * 0.18u' as='int((nf+2)/2) * W/nf * 0.18u' pd='2*int((nf+1)/2) * (W/nf + 0.18u)'
+ ps='2*int((nf+2)/2) * (W/nf + 0.18u)' nrd='0.18u / W' nrs='0.18u / W' sa=0 sb=0 sd=0 m=1
XMOKA NOKO NA TOK VDD pfet_03v3 L=4u W=8u nf=1 ad='int((nf+1)/2) * W/nf * 0.18u' as='int((nf+2)/2) * W/nf * 0.18u' pd='2*int((nf+1)/2) * (W/nf + 0.18u)'
+ ps='2*int((nf+2)/2) * (W/nf + 0.18u)' nrd='0.18u / W' nrs='0.18u / W' sa=0 sb=0 sd=0 m=1
XMOKB NOKL NBTOP TOK VDD pfet_03v3 L=4u W=8u nf=1 ad='int((nf+1)/2) * W/nf * 0.18u' as='int((nf+2)/2) * W/nf * 0.18u' pd='2*int((nf+1)/2) * (W/nf + 0.18u)'
+ ps='2*int((nf+2)/2) * (W/nf + 0.18u)' nrd='0.18u / W' nrs='0.18u / W' sa=0 sb=0 sd=0 m=1
XMOL1 NOKL NOKL VSS VSS nfet_03v3 L=4u W=2u nf=1 ad='int((nf+1)/2) * W/nf * 0.18u' as='int((nf+2)/2) * W/nf * 0.18u' pd='2*int((nf+1)/2) * (W/nf + 0.18u)'
+ ps='2*int((nf+2)/2) * (W/nf + 0.18u)' nrd='0.18u / W' nrs='0.18u / W' sa=0 sb=0 sd=0 m=1
XMOL2 NOKO NOKL VSS VSS nfet_03v3 L=4u W=2u nf=1 ad='int((nf+1)/2) * W/nf * 0.18u' as='int((nf+2)/2) * W/nf * 0.18u' pd='2*int((nf+1)/2) * (W/nf + 0.18u)'
+ ps='2*int((nf+2)/2) * (W/nf + 0.18u)' nrd='0.18u / W' nrs='0.18u / W' sa=0 sb=0 sd=0 m=1
XMOKC NOKO NKG VSS VSS nfet_03v3 L=1u W=2u nf=1 ad='int((nf+1)/2) * W/nf * 0.18u' as='int((nf+2)/2) * W/nf * 0.18u' pd='2*int((nf+1)/2) * (W/nf + 0.18u)'
+ ps='2*int((nf+2)/2) * (W/nf + 0.18u)' nrd='0.18u / W' nrs='0.18u / W' sa=0 sb=0 sd=0 m=1
XMOK2 NOKX NOKO VSS VSS nfet_03v3 L=4u W=2u nf=1 ad='int((nf+1)/2) * W/nf * 0.18u' as='int((nf+2)/2) * W/nf * 0.18u' pd='2*int((nf+1)/2) * (W/nf + 0.18u)'
+ ps='2*int((nf+2)/2) * (W/nf + 0.18u)' nrd='0.18u / W' nrs='0.18u / W' sa=0 sb=0 sd=0 m=1
XMOK2P NOKX PB VDD VDD pfet_03v3 L=4u W=1u nf=1 ad='int((nf+1)/2) * W/nf * 0.18u' as='int((nf+2)/2) * W/nf * 0.18u' pd='2*int((nf+1)/2) * (W/nf + 0.18u)'
+ ps='2*int((nf+2)/2) * (W/nf + 0.18u)' nrd='0.18u / W' nrs='0.18u / W' sa=0 sb=0 sd=0 m=1
XCOK VDD NOKX cap_mim_2f0_m3m4_noshield c_width=6u c_length=6u m=1
XMO1P BIAS_OK NOKX VDD VDD pfet_03v3 L=4u W=1u nf=1 ad='int((nf+1)/2) * W/nf * 0.18u' as='int((nf+2)/2) * W/nf * 0.18u' pd='2*int((nf+1)/2) * (W/nf + 0.18u)'
+ ps='2*int((nf+2)/2) * (W/nf + 0.18u)' nrd='0.18u / W' nrs='0.18u / W' sa=0 sb=0 sd=0 m=1
XMO1N BIAS_OK NOKX VSS VSS nfet_03v3 L=0.5u W=4u nf=1 ad='int((nf+1)/2) * W/nf * 0.18u' as='int((nf+2)/2) * W/nf * 0.18u' pd='2*int((nf+1)/2) * (W/nf + 0.18u)'
+ ps='2*int((nf+2)/2) * (W/nf + 0.18u)' nrd='0.18u / W' nrs='0.18u / W' sa=0 sb=0 sd=0 m=1
.ends
