* tb_por_ibias_sharing -- GENERATED by sim/build_tb.py
* Do not edit. Sources:
*   sim/por-output-chain-ibias-sharing/testbench/stimulus.spice
*   layout/postlayout/bias_core.spice  (sha256 88513e4f77055ad4361e63bec345ca8ad31d08881993813b3322772e8c63b18a)
*   layout/postlayout/temp_core.spice  (sha256 87f220c5391ecb4f0dbbe7d628119ec0dfd9ea0ca3115c70a6ce7436da73e6ae)
*   layout/postlayout/por_comparator.spice  (sha256 d19027352e24a2815800052d4735c6c51aef4595983cccc903da489fffca5ca9)
*   layout/postlayout/por_output_chain.spice  (sha256 52c3f7d5ad0eb31207dd6e43a9cd4211686f471359d3ad57816daabad357c52f)
* Regenerate with:
*   python3 sim/build_tb.py

* por-output-chain-ibias-sharing -- stimulus half of the testbench fragment.
*
* The other half is a verbatim copy of design/netlist/bias_core.spice,
* design/netlist/temp_core.spice, design/netlist/por_comparator.spice and
* design/netlist/por_output_chain.spice, appended by sim/build_tb.py to
* produce tb_por_ibias_sharing.spice. Edit THIS file (or the schematics),
* never the generated fragment.
*
* Netlist FRAGMENT: no .include / .lib / .temp / .control / .end -- the
* harness owns those. Parameters it supplies: vdd_val, vdd_nom, temp_c.
*
* WHY THIS EXPERIMENT EXISTS (issue #221)
*
* IBIAS is one shared net (DR-010): bias_core sources into it and temp_core,
* por_comparator and por_output_chain each hang their own mirror-input diode
* off it, so the source current splits. design/por_output_chain.md ("Hand-
* off to #11: the IBIAS envelope is the real constraint") derives that this
* cell's own deglitch dwell must not see IBIAS fall below about 0.44x
* nominal (500 nA nominal, so ~220 nA) at the SS/-40C corner, or the
* <=10us por-brownout ceiling is at risk. Nothing committed measures what
* current por_output_chain actually receives on the real assembly:
* sim/bias-core-ibias-sharing/ answers the *liveness* question (does the
* shared node survive a disabled temp_core, DR-010) but never instantiates
* por_output_chain and only reports the shared node's VOLTAGE, not any
* individual consumer's share of the current. This experiment closes that
* gap: it is a MAGNITUDE record, not a liveness one.
*
* Two branches, identical rail, differing only in temp_core's EN -- the
* same asserted/released distinction sim/bias-core-ibias-sharing/ already
* uses, extended to instantiate por_output_chain and to meter every
* consumer leg individually rather than only the shared node's voltage:
*
*   A. RESETn asserted: EN = 0. temp_core is high-Z per DR-010 (its XMBD's
*      gate is pinned to VSS through XMDNB once disabled, so it no longer
*      clamps the node -- the clamp DR-010 removed drew the whole
*      reference; the high-Z contract draws <=0.152 nA instead).
*   B. RESETn released: EN = 1. temp_core's own XMBD mirror diode rejoins
*      the shared node -- design/bias_core.md's "The shared IBIAS net"
*      measures the node stepping DOWN at release (temp_core's mirror
*      diode is a fourth load on a source that does not grow), which is
*      why released is expected to be the tighter of the two states.
*
* Neither branch closes the startup loop through por_output_chain's own
* RESETn output driving temp_core's EN pin back around (that closed-loop
* dynamic is sim/temp-por-top-release/'s job, and DR-016's XMRLK release
* latch already root-causes its transient behaviour). EN is DC-forced
* exactly as sim/bias-core-ibias-sharing/ already does, so this experiment
* isolates the STEADY-STATE current split at each state rather than the
* transient that connects them.
*
* Each leg gets its own zero-volt ammeter in series with the cell's IBIAS
* pin, all four tied to the same electrical node per branch (an ideal 0 V
* source adds no impedance), using the SAME sign convention
* sim/bias-core-ibias-sharing/ established: positive current means "flows
* from the shared node into this device" -- bias_core's own ammeter reads
* the total current it sources, and each consumer's ammeter reads what it
* draws from the shared node.
*
* The rail is ramped (not DC-stepped) so both branches start from a real
* cold start, exactly as sim/bias-core-ibias-sharing/ does; measurements are
* taken well after settling.

* ---- A. RESETn asserted (temp_core disabled) -------------------------
vsupa    vdda 0 PWL(0 0 100u {vdd_val} 1 {vdd_val})
vena     ena  0 dc 0
vibcorea nbcorea sharea dc 0
vibtmpa  sharea nibtmpa dc 0
vibcmpa  sharea nibcmpa dc 0
vibpora  sharea nibpora dc 0
xbiasa vdda 0 nbcorea vrefa oka          bias_core
xtempa vdda 0 nibtmpa ena ptata ctata    temp_core
xcmpa  vdda 0 nibcmpa vrefa oka por_rawa por_comparator
xpora  vdda 0 nibpora por_rawa resetna   por_output_chain
Rpta ptata 0 1T
Rcta ctata 0 1T

* ---- B. RESETn released (temp_core enabled) ---------------------------
vsupb    vddb 0 PWL(0 0 100u {vdd_val} 1 {vdd_val})
venb     enb  vddb dc 0
vibcoreb nbcoreb shareb dc 0
vibtmpb  shareb nibtmpb dc 0
vibcmpb  shareb nibcmpb dc 0
vibporb  shareb nibporb dc 0
xbiasb vddb 0 nbcoreb vrefb okb          bias_core
xtempb vddb 0 nibtmpb enb ptatb ctatb    temp_core
xcmpb  vddb 0 nibcmpb vrefb okb por_rawb por_comparator
xporb  vddb 0 nibporb por_rawb resetnb   por_output_chain
Rptb ptatb 0 1T
Rctb ctatb 0 1T

* bias_core -- post-layout netlist
* GENERATED by layout/postlayout.py -- do not edit.
*
* FROM THE LAYOUT: every device and its dimensions, the whole
*   topology, and first-order interconnect R/C on 47/54 nets
*   (sigma 1920.0 fF). klt 0.2.0, deck gf180mcu,
*   GDS sha256 215b742bbc05cfd0...
* Net names are the schematic's, restored through klt lvs's own net
*   correspondence -- match, 54/54 nets, every one paired.
*
* NOT FROM THE LAYOUT -- see layout/postlayout/AUDIT.md:
*   7 body/plate net(s) tied to the net the schematic puts
*   them on. The extraction deck's connectivity stack does not reach
*   an Nwell, a substrate ring, a bipolar base well or a MiM plate,
*   so they extract isolated and would otherwise float.
*   No ideal device: every golden device is drawn.
*
.subckt bias_core VDD VSS IBIAS VREF BIAS_OK

* --- drawn devices ---
X1 VDD VDD KS1 VSS nfet_03v3 L=8u W=1u nf=1 ad=0.8p as=0.8p pd=3.6u ps=3.6u m=1
X2 KS1 KS1 KS2 VSS nfet_03v3 L=8u W=1u nf=1 ad=0.8p as=0.8p pd=3.6u ps=3.6u m=1
X3 KS2 KS2 KS3 VSS nfet_03v3 L=8u W=1u nf=1 ad=0.8p as=0.8p pd=3.6u ps=3.6u m=1
X4 KS3 KS3 KS4 VSS nfet_03v3 L=8u W=1u nf=1 ad=0.8p as=0.8p pd=3.6u ps=3.6u m=1
X5 KS4 KS4 NKG VSS nfet_03v3 L=8u W=1u nf=1 ad=0.8p as=0.8p pd=3.6u ps=3.6u m=1
X6 PG NKG VSS VSS nfet_03v3 L=4u W=1u nf=1 ad=0.8p as=0.8p pd=3.6u ps=3.6u m=1
X7 NBG NBG VSS VSS nfet_03v3 L=4u W=2u nf=1 ad=1.6p as=1.6p pd=5.6u ps=5.6u m=1
X8 PB NBG VSS VSS nfet_03v3 L=4u W=2u nf=1 ad=1.6p as=1.6p pd=5.6u ps=5.6u m=1
X9 NKM NKM VSS VSS nfet_03v3 L=4u W=2u nf=1 ad=1.6p as=1.6p pd=5.6u ps=5.6u m=1
X10 NOKL NOKL VSS VSS nfet_03v3 L=4u W=2u nf=1 ad=1.6p as=1.6p pd=5.6u ps=5.6u m=1
X11 NOKO NOKL VSS VSS nfet_03v3 L=4u W=2u nf=1 ad=1.6p as=1.6p pd=5.6u ps=5.6u m=1
X12 NOKO NKG VSS VSS nfet_03v3 L=1u W=2u nf=1 ad=1.6p as=1.6p pd=5.6u ps=5.6u m=1
X13 NOKX NOKO VSS VSS nfet_03v3 L=4u W=2u nf=1 ad=1.6p as=1.6p pd=5.6u ps=5.6u m=1
X14 N1 N1 VSS VSS nfet_03v3 L=8u W=4u nf=1 ad=3.2p as=3.2p pd=9.6u ps=9.6u m=1
X15 N2 N1 VSS VSS nfet_03v3 L=8u W=4u nf=1 ad=3.2p as=3.2p pd=9.6u ps=9.6u m=1
X16 BIAS_OK NOKX VSS VSS nfet_03v3 L=0.5u W=4u nf=1 ad=3.2p as=3.2p pd=9.6u ps=9.6u m=1
X17 PG N2 VSS VSS nfet_03v3 L=8u W=8u nf=1 ad=6.4p as=6.4p pd=17.6u ps=17.6u m=1
X18 NKG NKM VSS VSS nfet_03v3 L=4u W=8u nf=1 ad=6.4p as=6.4p pd=17.6u ps=17.6u m=1
X19 NKM PB VDD VDD pfet_03v3 L=4u W=1u nf=1 ad=0.8p as=0.8p pd=3.6u ps=3.6u m=1
X20 TOK PB VDD VDD pfet_03v3 L=4u W=1u nf=1 ad=0.8p as=0.8p pd=3.6u ps=3.6u m=1
X21 NOKX PB VDD VDD pfet_03v3 L=4u W=1u nf=1 ad=0.8p as=0.8p pd=3.6u ps=3.6u m=1
X22 BIAS_OK NOKX VDD VDD pfet_03v3 L=4u W=1u nf=1 ad=0.8p as=0.8p pd=3.6u ps=3.6u m=1
X23 NBG PG VDD VDD pfet_03v3 L=4u W=2u nf=1 ad=1.6p as=1.6p pd=5.6u ps=5.6u m=1
X24 PB PB VDD VDD pfet_03v3 L=4u W=2u nf=1 ad=1.6p as=1.6p pd=5.6u ps=5.6u m=1
X25 NT PB VDD VDD pfet_03v3 L=4u W=2u nf=1 ad=1.6p as=1.6p pd=5.6u ps=5.6u m=1
X26 PG PB VDD VDD pfet_03v3 L=4u W=2u nf=1 ad=1.6p as=1.6p pd=5.6u ps=5.6u m=1
X27 NA PG VDD VDD pfet_03v3 L=4u W=8u nf=1 ad=6.4p as=6.4p pd=17.6u ps=17.6u m=1
X28 NBTOP PG VDD VDD pfet_03v3 L=4u W=8u nf=1 ad=6.4p as=6.4p pd=17.6u ps=17.6u m=1
X29 VREF PG VDD VDD pfet_03v3 L=4u W=8u nf=1 ad=6.4p as=6.4p pd=17.6u ps=17.6u m=1
X30 NOKO NA TOK VDD pfet_03v3 L=4u W=8u nf=1 ad=6.4p as=6.4p pd=17.6u ps=17.6u m=1
X31 NOKL NBTOP TOK VDD pfet_03v3 L=4u W=8u nf=1 ad=6.4p as=6.4p pd=17.6u ps=17.6u m=1
X32 N1 NA NT VDD pfet_03v3 L=4u W=16u nf=1 ad=12.8p as=12.8p pd=33.6u ps=33.6u m=1
X33 N2 NB NT VDD pfet_03v3 L=4u W=16u nf=1 ad=12.8p as=12.8p pd=33.6u ps=33.6u m=1
X34 IBIAS PB VDD VDD pfet_03v3 L=4u W=40u nf=1 ad=32p as=32p pd=81.6u ps=81.6u m=1
X35 VSS VSS EC pnp_10p00x10p00
X36 VSS VSS EC pnp_10p00x10p00
X37 VSS VSS EC pnp_10p00x10p00
X38 VSS VSS EC pnp_10p00x10p00
X39 VSS VSS NA pnp_10p00x10p00
X40 VSS VSS EC pnp_10p00x10p00
X41 VSS VSS ER pnp_10p00x10p00
X42 VSS VSS EC pnp_10p00x10p00
X43 VSS VSS EC pnp_10p00x10p00
X44 VSS VSS EC pnp_10p00x10p00
X45 NOKX VDD cap_mim_2f0_m3m4_noshield c_width=6u c_length=6u
X46 NZ PG cap_mim_2f0_m3m4_noshield c_width=20u c_length=20u
X47 VREF XR2__1 VSS ppolyf_u_3k r_width=2u r_length=256.5u
X48 XR2__2 XR2__1 VSS ppolyf_u_3k r_width=2u r_length=256.5u
X49 XR2__2 XR2__3 VSS ppolyf_u_3k r_width=2u r_length=256.5u
X50 XR2__4 XR2__3 VSS ppolyf_u_3k r_width=2u r_length=256.5u
X51 XR2__4 XR2__5 VSS ppolyf_u_3k r_width=2u r_length=256.5u
X52 XR2__6 XR2__5 VSS ppolyf_u_3k r_width=2u r_length=256.5u
X53 XR2__6 XR2__7 VSS ppolyf_u_3k r_width=2u r_length=256.5u
X54 XR2__8 XR2__7 VSS ppolyf_u_3k r_width=2u r_length=256.5u
X55 XR2__8 XR2__9 VSS ppolyf_u_3k r_width=2u r_length=256.5u
X56 XR2__10 XR2__9 VSS ppolyf_u_3k r_width=2u r_length=256.5u
X57 XR2__10 XR2__11 VSS ppolyf_u_3k r_width=2u r_length=256.5u
X58 XR2__12 XR2__11 VSS ppolyf_u_3k r_width=2u r_length=256.5u
X59 XR2__12 XR2__13 VSS ppolyf_u_3k r_width=2u r_length=256.5u
X60 XR2__14 XR2__13 VSS ppolyf_u_3k r_width=2u r_length=256.5u
X61 XR2__14 XR2__15 VSS ppolyf_u_3k r_width=2u r_length=256.5u
X62 ER XR2__15 VSS ppolyf_u_3k r_width=2u r_length=256.5u
X63 NZ XRZ__1 VSS ppolyf_u_3k r_width=2u r_length=254u
X64 XRZ__2 XRZ__1 VSS ppolyf_u_3k r_width=2u r_length=254u
X65 XRZ__2 XRZ__3 VSS ppolyf_u_3k r_width=2u r_length=254u
X66 N2 XRZ__3 VSS ppolyf_u_3k r_width=2u r_length=254u
X67 NB XR1__1 VSS ppolyf_u_3k r_width=2u r_length=175u
X68 EC XR1__1 VSS ppolyf_u_3k r_width=2u r_length=175u
X69 NBTOP XRT__1 VSS ppolyf_u_3k r_width=2u r_length=8.75u
X70 NB XRT__1 VSS ppolyf_u_3k r_width=2u r_length=8.75u

R_10 N1 N1__par 4967.8583
C_10 N1__par VSS 5.978126e-14
R_11 N2 N2__par 7855.0506
C_11 N2__par VSS 8.4779094e-14
R_12 NKM NKM__par 4876.8874
C_12 NKM__par VSS 5.7923066e-14
R_13 TOK TOK__par 4690.5254
C_13 TOK__par VSS 5.2350545e-14
R_14 NOKO NOKO__par 4792.4183
C_14 NOKO__par VSS 5.9161863e-14
R_15 NOKL NOKL__par 4883.997
C_15 NOKL__par VSS 6.0794305e-14
R_16 NOKX NOKX__par 4848.4085
C_16 NOKX__par VSS 5.9751918e-14
R_17 KS1 KS1__par 4818.8511
C_17 KS1__par VSS 5.4330567e-14
R_18 KS2 KS2__par 4819.3911
C_18 KS2__par VSS 5.4548635e-14
R_19 KS3 KS3__par 4819.931
C_19 KS3__par VSS 5.4766704e-14
R_20 KS4 KS4__par 4820.471
C_20 KS4__par VSS 5.4984773e-14
R_21 NKG NKG__par 4848.0503
C_21 NKG__par VSS 5.7785044e-14
R_23 NB NB__par 7667.0394
C_23 NB__par VSS 7.6118691e-14
R_24 EC EC__par 2791.7858
C_24 EC__par VSS 7.4268842e-14
R_25 NZ NZ__par 2787.2554
C_25 NZ__par VSS 2.545538e-14
R_27 XRZ__2 XRZ__2__par 18.25
C_27 XRZ__2__par VSS 1.8067e-15
R_28 XR2__14 XR2__14__par 18.25
C_28 XR2__14__par VSS 1.8067e-15
R_29 XR2__12 XR2__12__par 18.25
C_29 XR2__12__par VSS 1.8067e-15
R_3 PG PG__par 5084.0134
C_3 PG__par VSS 6.8147207e-14
R_30 XR2__10 XR2__10__par 18.25
C_30 XR2__10__par VSS 1.8067e-15
R_31 XR2__8 XR2__8__par 18.25
C_31 XR2__8__par VSS 1.8067e-15
R_32 XR2__6 XR2__6__par 18.25
C_32 XR2__6__par VSS 1.8067e-15
R_33 XR2__4 XR2__4__par 18.25
C_33 XR2__4__par VSS 1.8067e-15
R_34 XR2__2 XR2__2__par 18.25
C_34 XR2__2__par VSS 1.8067e-15
R_35 NA NA__par 8008.5898
C_35 NA__par VSS 8.7590412e-14
R_36 ER ER__par 2787.674
C_36 ER__par VSS 3.3170077e-14
R_37 XRT__1 XRT__1__par 18.25
C_37 XRT__1__par VSS 1.8067e-15
R_4 NBTOP NBTOP__par 7796.7657
C_4 NBTOP__par VSS 7.8325844e-14
R_43 XR1__1 XR1__1__par 18.25
C_43 XR1__1__par VSS 1.8067e-15
R_44 XRZ__3 XRZ__3__par 18.25
C_44 XRZ__3__par VSS 1.8067e-15
R_45 XRZ__1 XRZ__1__par 18.25
C_45 XRZ__1__par VSS 1.8067e-15
R_46 XR2__13 XR2__13__par 18.25
C_46 XR2__13__par VSS 1.8067e-15
R_47 XR2__11 XR2__11__par 18.25
C_47 XR2__11__par VSS 1.8067e-15
R_48 XR2__1 XR2__1__par 18.25
C_48 XR2__1__par VSS 1.8067e-15
R_49 XR2__3 XR2__3__par 18.25
C_49 XR2__3__par VSS 1.8067e-15
R_50 XR2__5 XR2__5__par 18.25
C_50 XR2__5__par VSS 1.8067e-15
R_51 XR2__7 XR2__7__par 18.25
C_51 XR2__7__par VSS 1.8067e-15
R_52 XR2__9 XR2__9__par 18.25
C_52 XR2__9__par VSS 1.8067e-15
R_53 XR2__15 XR2__15__par 18.25
C_53 XR2__15__par VSS 1.8067e-15
R_6 NBG NBG__par 4871.7578
C_6 NBG__par VSS 5.5851412e-14
R_7 PB PB__par 5396.0003
C_7 PB__par VSS 7.9168117e-14
R_9 NT NT__par 4684.5858
C_9 NT__par VSS 4.9951788e-14
RBIAS_OK BIAS_OK BIAS_OK__par 4679.0384
CBIAS_OK BIAS_OK__par VSS 4.7753184e-14
RIBIAS IBIAS IBIAS__par 4663.4113
CIBIAS IBIAS__par VSS 4.1483963e-14
RVDD VDD VDD__par 371.4414
CVDD VDD__par VSS 1.29011679e-13
RVREF VREF VREF__par 7695.5815
CVREF VREF__par VSS 7.3513489e-14
RVSS VSS VSS__par 145.0127
CVSS VSS__par VSS 2.53079568e-13
.ends bias_core

* temp_core -- post-layout netlist
* GENERATED by layout/postlayout.py -- do not edit.
*
* FROM THE LAYOUT: every device and its dimensions, the whole
*   topology, and first-order interconnect R/C on 69/73 nets
*   (sigma 1552.3 fF). klt 0.2.0, deck gf180mcu,
*   GDS sha256 852d534c2004326c...
* Net names are the schematic's, restored through klt lvs's own net
*   correspondence -- match, 73/73 nets, every one paired.
*
* NOT FROM THE LAYOUT -- see layout/postlayout/AUDIT.md:
*   4 body/plate net(s) tied to the net the schematic puts
*   them on. The extraction deck's connectivity stack does not reach
*   an Nwell, a substrate ring, a bipolar base well or a MiM plate,
*   so they extract isolated and would otherwise float.
*   XCC (cap_mim_2f0_m3m4_noshield) is IDEAL -- not drawn in this cell's layout -- reserved floor area.
*
.subckt temp_core VDD VSS IBIAS EN PTAT CTAT

* --- schematic-ideal, not drawn ---
XIDEAL1 PG NZ cap_mim_2f0_m3m4_noshield c_width=12u c_length=12u

* --- drawn devices ---
X1 VSS VSS VSS VSS nfet_03v3 L=8u W=4u nf=1 ad=3.2p as=3.2p pd=9.6u ps=9.6u m=1
X2 N1 N1 VSS VSS nfet_03v3 L=8u W=4u nf=1 ad=3.2p as=3.2p pd=9.6u ps=9.6u m=1
X3 N2 N1 VSS VSS nfet_03v3 L=8u W=4u nf=1 ad=3.2p as=3.2p pd=9.6u ps=9.6u m=1
X4 N2 N1 VSS VSS nfet_03v3 L=8u W=4u nf=1 ad=3.2p as=3.2p pd=9.6u ps=9.6u m=1
X5 N1 N1 VSS VSS nfet_03v3 L=8u W=4u nf=1 ad=3.2p as=3.2p pd=9.6u ps=9.6u m=1
X6 VSS VSS VSS VSS nfet_03v3 L=8u W=4u nf=1 ad=3.2p as=3.2p pd=9.6u ps=9.6u m=1
X7 PG N2 VSS VSS nfet_03v3 L=8u W=8u nf=1 ad=6.4p as=6.4p pd=17.6u ps=17.6u m=1
X8 IBIAS NBG VSS VSS nfet_03v3 L=2u W=4u nf=1 ad=3.2p as=3.2p pd=9.6u ps=9.6u m=1
X9 IBIAS EN NBG VSS nfet_03v3 L=0.5u W=2u nf=1 ad=1.6p as=1.6p pd=5.6u ps=5.6u m=1
X10 NBG ENB VSS VSS nfet_03v3 L=0.5u W=2u nf=1 ad=1.6p as=1.6p pd=5.6u ps=5.6u m=1
X11 PB NBG VSS VSS nfet_03v3 L=2u W=4u nf=1 ad=3.2p as=3.2p pd=9.6u ps=9.6u m=1
X12 PCAS NBG VSS VSS nfet_03v3 L=2u W=4u nf=1 ad=3.2p as=3.2p pd=9.6u ps=9.6u m=1
X13 ENB EN VSS VSS nfet_03v3 L=0.5u W=1u nf=1 ad=0.8p as=0.8p pd=3.6u ps=3.6u m=1
X14 ND NR VSS VSS nfet_03v3 L=2u W=2u nf=1 ad=1.6p as=1.6p pd=5.6u ps=5.6u m=1
X15 PG ND VSS VSS nfet_03v3 L=1u W=4u nf=1 ad=3.2p as=3.2p pd=9.6u ps=9.6u m=1
X16 NR NR VSS VSS nfet_03v3 L=2u W=2u nf=1 ad=1.6p as=1.6p pd=5.6u ps=5.6u m=1
X17 ND ENB VSS VSS nfet_03v3 L=0.5u W=2u nf=1 ad=1.6p as=1.6p pd=5.6u ps=5.6u m=1
X18 PTAT ENB VSS VSS nfet_03v3 L=1u W=1u nf=1 ad=0.8p as=0.8p pd=3.6u ps=3.6u m=1
X19 CTAT ENB VSS VSS nfet_03v3 L=1u W=1u nf=1 ad=0.8p as=0.8p pd=3.6u ps=3.6u m=1
X20 N2 ENB VSS VSS nfet_03v3 L=1u W=2u nf=1 ad=1.6p as=1.6p pd=5.6u ps=5.6u m=1
X21 NT ENB VSS VSS nfet_03v3 L=1u W=2u nf=1 ad=1.6p as=1.6p pd=5.6u ps=5.6u m=1
X22 T5 VDD T4 VSS nfet_03v3 L=0.5u W=32u nf=1 ad=25.6p as=25.6p pd=65.6u ps=65.6u m=1
X23 T3 VSS T2 VSS nfet_03v3 L=0.5u W=32u nf=1 ad=25.6p as=25.6p pd=65.6u ps=65.6u m=1
X24 T1 VSS T0 VSS nfet_03v3 L=0.5u W=32u nf=1 ad=25.6p as=25.6p pd=65.6u ps=65.6u m=1
X25 T0 VSS VSS VSS nfet_03v3 L=0.5u W=32u nf=1 ad=25.6p as=25.6p pd=65.6u ps=65.6u m=1
X26 T2 VSS T1 VSS nfet_03v3 L=0.5u W=32u nf=1 ad=25.6p as=25.6p pd=65.6u ps=65.6u m=1
X27 T4 VSS T3 VSS nfet_03v3 L=0.5u W=32u nf=1 ad=25.6p as=25.6p pd=65.6u ps=65.6u m=1
X28 NT NT NT NT pfet_03v3 L=4u W=16u nf=1 ad=12.8p as=12.8p pd=33.6u ps=33.6u m=1
X29 N1 NA NT NT pfet_03v3 L=4u W=16u nf=1 ad=12.8p as=12.8p pd=33.6u ps=33.6u m=1
X30 N2 NB NT NT pfet_03v3 L=4u W=16u nf=1 ad=12.8p as=12.8p pd=33.6u ps=33.6u m=1
X31 N2 NB NT NT pfet_03v3 L=4u W=16u nf=1 ad=12.8p as=12.8p pd=33.6u ps=33.6u m=1
X32 N1 NA NT NT pfet_03v3 L=4u W=16u nf=1 ad=12.8p as=12.8p pd=33.6u ps=33.6u m=1
X33 NT NT NT NT pfet_03v3 L=4u W=16u nf=1 ad=12.8p as=12.8p pd=33.6u ps=33.6u m=1
X34 NT PB VDD VDD pfet_03v3 L=4u W=20u nf=1 ad=16p as=16p pd=41.6u ps=41.6u m=1
X35 VDD VDD VDD VDD pfet_03v3 L=4u W=4u nf=1 ad=3.2p as=3.2p pd=9.6u ps=9.6u m=1
X36 M1D PG VDD VDD pfet_03v3 L=4u W=4u nf=1 ad=3.2p as=3.2p pd=9.6u ps=9.6u m=1
X37 NA PCAS M1D VDD pfet_03v3 L=1u W=4u nf=1 ad=3.2p as=3.2p pd=9.6u ps=9.6u m=1
X38 M2D PG VDD VDD pfet_03v3 L=4u W=4u nf=1 ad=3.2p as=3.2p pd=9.6u ps=9.6u m=1
X39 NB PCAS M2D VDD pfet_03v3 L=1u W=4u nf=1 ad=3.2p as=3.2p pd=9.6u ps=9.6u m=1
X40 M3D PG VDD VDD pfet_03v3 L=4u W=4u nf=1 ad=3.2p as=3.2p pd=9.6u ps=9.6u m=1
X41 PTAT PCAS M3D VDD pfet_03v3 L=1u W=4u nf=1 ad=3.2p as=3.2p pd=9.6u ps=9.6u m=1
X42 PTAT PCAS M3D VDD pfet_03v3 L=1u W=4u nf=1 ad=3.2p as=3.2p pd=9.6u ps=9.6u m=1
X43 M3D PG VDD VDD pfet_03v3 L=4u W=4u nf=1 ad=3.2p as=3.2p pd=9.6u ps=9.6u m=1
X44 NB PCAS M2D VDD pfet_03v3 L=1u W=4u nf=1 ad=3.2p as=3.2p pd=9.6u ps=9.6u m=1
X45 M2D PG VDD VDD pfet_03v3 L=4u W=4u nf=1 ad=3.2p as=3.2p pd=9.6u ps=9.6u m=1
X46 NA PCAS M1D VDD pfet_03v3 L=1u W=4u nf=1 ad=3.2p as=3.2p pd=9.6u ps=9.6u m=1
X47 M1D PG VDD VDD pfet_03v3 L=4u W=4u nf=1 ad=3.2p as=3.2p pd=9.6u ps=9.6u m=1
X48 VDD VDD VDD VDD pfet_03v3 L=4u W=4u nf=1 ad=3.2p as=3.2p pd=9.6u ps=9.6u m=1
X49 PG PB VDD VDD pfet_03v3 L=4u W=10u nf=1 ad=8p as=8p pd=21.6u ps=21.6u m=1
X50 PB PB VDD VDD pfet_03v3 L=4u W=10u nf=1 ad=8p as=8p pd=21.6u ps=21.6u m=1
X51 PCAS PCAS VDD VDD pfet_03v3 L=8u W=1u nf=1 ad=0.8p as=0.8p pd=3.6u ps=3.6u m=1
X52 ENB EN VDD VDD pfet_03v3 L=0.5u W=2u nf=1 ad=1.6p as=1.6p pd=5.6u ps=5.6u m=1
X53 ND PB VDD VDD pfet_03v3 L=8u W=1u nf=1 ad=0.8p as=0.8p pd=3.6u ps=3.6u m=1
X54 NR PG VDD VDD pfet_03v3 L=4u W=1u nf=1 ad=0.8p as=0.8p pd=3.6u ps=3.6u m=1
X55 PG EN VDD VDD pfet_03v3 L=0.5u W=4u nf=1 ad=3.2p as=3.2p pd=9.6u ps=9.6u m=1
X56 VSS VSS NC pnp_10p00x10p00
X57 VSS VSS NC pnp_10p00x10p00
X58 VSS VSS NC pnp_10p00x10p00
X59 VSS VSS NC pnp_10p00x10p00
X60 VSS VSS NA pnp_10p00x10p00
X61 VSS VSS NC pnp_10p00x10p00
X62 VSS VSS NC pnp_10p00x10p00
X63 VSS VSS NC pnp_10p00x10p00
X64 VSS VSS NC pnp_10p00x10p00
X65 NB XR1__1 VSS ppolyf_u r_width=2u r_length=59.735u
X66 NC XR1__1 VSS ppolyf_u r_width=2u r_length=59.735u
X67 NA XRISO__1 VSS ppolyf_u r_width=2u r_length=55.525u
X68 CTAT XRISO__1 VSS ppolyf_u r_width=2u r_length=55.525u
X69 NZ XRZ__1 VSS ppolyf_u r_width=2u r_length=100u
X70 XRZ__2 XRZ__1 VSS ppolyf_u r_width=2u r_length=100u
X71 XRZ__2 XRZ__3 VSS ppolyf_u r_width=2u r_length=100u
X72 XRZ__4 XRZ__3 VSS ppolyf_u r_width=2u r_length=100u
X73 XRZ__4 XRZ__5 VSS ppolyf_u r_width=2u r_length=100u
X74 XRZ__6 XRZ__5 VSS ppolyf_u r_width=2u r_length=100u
X75 XRZ__6 XRZ__7 VSS ppolyf_u r_width=2u r_length=100u
X76 XRZ__8 XRZ__7 VSS ppolyf_u r_width=2u r_length=100u
X77 XRZ__8 XRZ__9 VSS ppolyf_u r_width=2u r_length=100u
X78 N2 XRZ__9 VSS ppolyf_u r_width=2u r_length=100u
X79 PTAT XR2F__1 VSS ppolyf_u r_width=2u r_length=110.525u
X80 XR2F__2 XR2F__1 VSS ppolyf_u r_width=2u r_length=110.525u
X81 XR2F__2 XR2F__3 VSS ppolyf_u r_width=2u r_length=110.525u
X82 XR2F__4 XR2F__3 VSS ppolyf_u r_width=2u r_length=110.525u
X83 XR2F__4 XR2F__5 VSS ppolyf_u r_width=2u r_length=110.525u
X84 XR2F__6 XR2F__5 VSS ppolyf_u r_width=2u r_length=110.525u
X85 XR2F__6 XR2F__7 VSS ppolyf_u r_width=2u r_length=110.525u
X86 XR2F__8 XR2F__7 VSS ppolyf_u r_width=2u r_length=110.525u
X87 XR2F__8 XR2F__9 VSS ppolyf_u r_width=2u r_length=110.525u
X88 XR2F__10 XR2F__9 VSS ppolyf_u r_width=2u r_length=110.525u
X89 XR2F__10 XR2F__11 VSS ppolyf_u r_width=2u r_length=110.525u
X90 XR2F__12 XR2F__11 VSS ppolyf_u r_width=2u r_length=110.525u
X91 XR2F__12 XR2F__13 VSS ppolyf_u r_width=2u r_length=110.525u
X92 XR2F__14 XR2F__13 VSS ppolyf_u r_width=2u r_length=110.525u
X93 XR2F__14 XR2F__15 VSS ppolyf_u r_width=2u r_length=110.525u
X94 XR2F__16 XR2F__15 VSS ppolyf_u r_width=2u r_length=110.525u
X95 XR2F__16 XR2F__17 VSS ppolyf_u r_width=2u r_length=110.525u
X96 XR2F__18 XR2F__17 VSS ppolyf_u r_width=2u r_length=110.525u
X97 XR2F__18 XR2F__19 VSS ppolyf_u r_width=2u r_length=110.525u
X98 XR2F__20 XR2F__19 VSS ppolyf_u r_width=2u r_length=110.525u
X99 XR2F__20 XR2F__21 VSS ppolyf_u r_width=2u r_length=110.525u
X100 XR2F__22 XR2F__21 VSS ppolyf_u r_width=2u r_length=110.525u
X101 XR2F__22 XR2F__23 VSS ppolyf_u r_width=2u r_length=110.525u
X102 T5 XR2F__23 VSS ppolyf_u r_width=2u r_length=110.525u
X103 T5 XR2T5__1 VSS ppolyf_u r_width=2u r_length=114.855u
X104 T4 XR2T5__1 VSS ppolyf_u r_width=2u r_length=114.855u
X105 T4 XR2T4__1 VSS ppolyf_u r_width=2u r_length=57.345u
X106 T3 XR2T4__1 VSS ppolyf_u r_width=2u r_length=57.345u
X107 T3 XR2T3__1 VSS ppolyf_u r_width=2u r_length=28.59u
X108 T2 XR2T3__1 VSS ppolyf_u r_width=2u r_length=28.59u
X109 T2 XR2T2__1 VSS ppolyf_u r_width=2u r_length=14.21u
X110 T1 XR2T2__1 VSS ppolyf_u r_width=2u r_length=14.21u
X111 T1 XR2T1__1 VSS ppolyf_u r_width=2u r_length=7.015u
X112 T0 XR2T1__1 VSS ppolyf_u r_width=2u r_length=7.015u
X113 T0 XR2T0__1 VSS ppolyf_u r_width=2u r_length=3.425u
X114 VSS XR2T0__1 VSS ppolyf_u r_width=2u r_length=3.425u

R_30 XRZ__2 XRZ__2__par 50.5749
C_30 XRZ__2__par VSS 1.599507e-15
R_31 XRZ__4 XRZ__4__par 50.5749
C_31 XRZ__4__par VSS 1.599507e-15
R_32 XRZ__6 XRZ__6__par 50.5749
C_32 XRZ__6__par VSS 1.599507e-15
R_33 XRZ__8 XRZ__8__par 50.5749
C_33 XRZ__8__par VSS 1.599507e-15
R_34 XR2F__2 XR2F__2__par 50.5749
C_34 XR2F__2__par VSS 1.599507e-15
R_35 XR2F__4 XR2F__4__par 50.5749
C_35 XR2F__4__par VSS 1.599507e-15
R_36 XR2F__6 XR2F__6__par 50.5749
C_36 XR2F__6__par VSS 1.599507e-15
R_37 XR2F__8 XR2F__8__par 50.5749
C_37 XR2F__8__par VSS 1.599507e-15
R_38 XR2F__10 XR2F__10__par 50.5749
C_38 XR2F__10__par VSS 1.599507e-15
R_39 XR2F__12 XR2F__12__par 50.5749
C_39 XR2F__12__par VSS 1.599507e-15
R_40 XR2F__14 XR2F__14__par 50.5749
C_40 XR2F__14__par VSS 1.599507e-15
R_41 XR2F__16 XR2F__16__par 50.5749
C_41 XR2F__16__par VSS 1.599507e-15
R_42 XR2F__18 XR2F__18__par 50.5749
C_42 XR2F__18__par VSS 1.599507e-15
R_43 XR2F__20 XR2F__20__par 50.5749
C_43 XR2F__20__par VSS 1.599507e-15
R_44 XR2F__22 XR2F__22__par 50.5749
C_44 XR2F__22__par VSS 1.599507e-15
R_50 XR2T0__1 XR2T0__1__par 50.5749
C_50 XR2T0__1__par VSS 1.599507e-15
R_51 XR2T1__1 XR2T1__1__par 50.5749
C_51 XR2T1__1__par VSS 1.599507e-15
R_56 XR2T2__1 XR2T2__1__par 50.5749
C_56 XR2T2__1__par VSS 1.599507e-15
R_60 XR2T3__1 XR2T3__1__par 50.5749
C_60 XR2T3__1__par VSS 1.599507e-15
R_68 XRISO__1 XRISO__1__par 50.5749
C_68 XRISO__1__par VSS 1.599507e-15
R_69 XR2T4__1 XR2T4__1__par 50.5749
C_69 XR2T4__1__par VSS 1.599507e-15
R_70 XR1__1 XR1__1__par 50.5749
C_70 XR1__1__par VSS 1.599507e-15
R_71 XRZ__1 XRZ__1__par 50.5749
C_71 XRZ__1__par VSS 1.599507e-15
R_72 XRZ__3 XRZ__3__par 50.5749
C_72 XRZ__3__par VSS 1.599507e-15
R_73 XRZ__5 XRZ__5__par 50.5749
C_73 XRZ__5__par VSS 1.599507e-15
R_74 XRZ__7 XRZ__7__par 50.5749
C_74 XRZ__7__par VSS 1.599507e-15
R_75 XRZ__9 XRZ__9__par 50.5749
C_75 XRZ__9__par VSS 1.599507e-15
R_76 XR2F__1 XR2F__1__par 50.5749
C_76 XR2F__1__par VSS 1.599507e-15
R_77 XR2F__3 XR2F__3__par 50.5749
C_77 XR2F__3__par VSS 1.599507e-15
R_78 XR2F__5 XR2F__5__par 50.5749
C_78 XR2F__5__par VSS 1.599507e-15
R_79 XR2F__7 XR2F__7__par 50.5749
C_79 XR2F__7__par VSS 1.599507e-15
R_80 XR2F__9 XR2F__9__par 50.5749
C_80 XR2F__9__par VSS 1.599507e-15
R_81 XR2F__11 XR2F__11__par 50.5749
C_81 XR2F__11__par VSS 1.599507e-15
R_82 XR2F__13 XR2F__13__par 50.5749
C_82 XR2F__13__par VSS 1.599507e-15
R_83 XR2F__15 XR2F__15__par 50.5749
C_83 XR2F__15__par VSS 1.599507e-15
R_84 XR2F__17 XR2F__17__par 50.5749
C_84 XR2F__17__par VSS 1.599507e-15
R_85 XR2F__19 XR2F__19__par 50.5749
C_85 XR2F__19__par VSS 1.599507e-15
R_86 XR2F__21 XR2F__21__par 50.5749
C_86 XR2F__21__par VSS 1.599507e-15
R_87 XR2F__23 XR2F__23__par 50.5749
C_87 XR2F__23__par VSS 1.599507e-15
R_88 XR2T5__1 XR2T5__1__par 50.5749
C_88 XR2T5__1__par VSS 1.599507e-15
RCTAT CTAT CTAT__par 508.901
CCTAT CTAT__par VSS 3.2409351e-14
REN EN EN__par 1473.1873
CEN EN__par VSS 3.3733752e-14
RENB ENB ENB__par 1722.3174
CENB ENB__par VSS 3.6434644e-14
RIBIAS IBIAS IBIAS__par 322.6504
CIBIAS IBIAS__par VSS 2.0287657e-14
RM1D M1D M1D__par 1326.5002
CM1D M1D__par VSS 2.6584926e-14
RM2D M2D M2D__par 1250.9542
CM2D M2D__par VSS 2.5194004e-14
RM3D M3D M3D__par 1175.4138
CM3D M3D__par VSS 2.3803081e-14
RN1 N1 N1__par 3916.0744
CN1 N1__par VSS 3.9166451e-14
RN2 N2 N2__par 2349.712
CN2 N2__par VSS 5.2203575e-14
RNA NA NA__par 2133.218
CNA NA__par VSS 6.3089263e-14
RNB NB NB__par 2057.3709
CNB NB__par VSS 4.3487422e-14
RNBG NBG NBG__par 1144.9314
CNBG NBG__par VSS 2.6946068e-14
RNC NC NC__par 65.9407
CNC NC__par VSS 8.5417204e-14
RND ND ND__par 1512.6715
CND ND__par VSS 3.4769335e-14
RNR NR NR__par 1694.9168
CNR NR__par VSS 3.5399052e-14
RNT NT NT__par 5451.5605
CNT NT__par VSS 7.8898189e-14
RNZ NZ NZ__par 105.4542
CNZ NZ__par VSS 2.9318592e-14
RPB PB PB__par 3535.6753
CPB PB__par VSS 4.7145745e-14
RPCAS PCAS PCAS__par 4548.8647
CPCAS PCAS__par VSS 5.3738496e-14
RPG PG PG__par 5100.5412
CPG PG__par VSS 6.1711967e-14
RPTAT PTAT PTAT__par 962.4337
CPTAT PTAT__par VSS 3.9542032e-14
RT0 T0 T0__par 1253.0071
CT0 T0__par VSS 5.5998739e-14
RT1 T1 T1__par 1214.9021
CT1 T1__par VSS 5.5179431e-14
RT2 T2 T2__par 1176.8024
CT2 T2__par VSS 5.4360123e-14
RT3 T3 T3__par 1138.7083
CT3 T3__par VSS 5.3540815e-14
RT4 T4 T4__par 1100.6204
CT4 T4__par VSS 5.2721507e-14
RT5 T5 T5__par 607.3914
CT5 T5__par VSS 4.5515196e-14
RVDD VDD VDD__par 11776.8157
CVDD VDD__par VSS 1.23638547e-13
RVSS VSS VSS__par 3083.8865
CVSS VSS__par VSS 1.58058319e-13
.ends temp_core

* por_comparator -- post-layout netlist
* GENERATED by layout/postlayout.py -- do not edit.
*
* FROM THE LAYOUT: every device and its dimensions, the whole
*   topology, and first-order interconnect R/C on 15/18 nets
*   (sigma 472.9 fF). klt 0.2.0, deck gf180mcu,
*   GDS sha256 c60a2ef35e34d6d4...
* Net names are the schematic's, restored through klt lvs's own net
*   correspondence -- match, 18/18 nets, every one paired.
*
* NOT FROM THE LAYOUT -- see layout/postlayout/AUDIT.md:
*   3 body/plate net(s) tied to the net the schematic puts
*   them on. The extraction deck's connectivity stack does not reach
*   an Nwell, a substrate ring, a bipolar base well or a MiM plate,
*   so they extract isolated and would otherwise float.
*   No ideal device: every golden device is drawn.
*
.subckt por_comparator VDD VSS IBIAS VREF BIAS_OK POR_RAW

* --- drawn devices ---
X1 TN NBG VSS VSS nfet_03v3 L=10u W=1u nf=1 ad=0.8p as=0.8p pd=3.6u ps=3.6u m=1
X2 IBIAS BIAS_OKB VSS VSS nfet_03v3 L=1u W=1u nf=1 ad=0.8p as=0.8p pd=3.6u ps=3.6u m=1
X3 N1 CMPO VSS VSS nfet_03v3 L=0.5u W=1u nf=1 ad=0.8p as=0.8p pd=3.6u ps=3.6u m=1
X4 POR_RAW N1 VSS VSS nfet_03v3 L=0.5u W=1u nf=1 ad=0.8p as=0.8p pd=3.6u ps=3.6u m=1
X5 BIAS_OKB BIAS_OK VSS VSS nfet_03v3 L=0.5u W=1u nf=1 ad=0.8p as=0.5p pd=3.6u ps=3u m=1
X6 NA SNS TN VSS nfet_03v3 L=1u W=2u nf=1 ad=1.6p as=1.6p pd=5.6u ps=5.6u m=1
X7 CMPO VREF TN VSS nfet_03v3 L=1u W=2u nf=1 ad=1.6p as=1.6p pd=5.6u ps=5.6u m=1
X8 IBIAS NBG VSS VSS nfet_03v3 L=2u W=2u nf=1 ad=1.6p as=1.6p pd=5.6u ps=5.6u m=1
X9 IBIAS BIAS_OK NBG VSS nfet_03v3 L=0.5u W=2u nf=1 ad=1.6p as=1.6p pd=5.6u ps=5.6u m=1
X10 NBG BIAS_OKB VSS VSS nfet_03v3 L=0.5u W=2u nf=1 ad=1.6p as=1.6p pd=5.6u ps=5.6u m=1
X11 CMPO BIAS_OKB VSS VSS nfet_03v3 L=1u W=2u nf=1 ad=1.6p as=1.6p pd=5.6u ps=5.6u m=1
X12 SNSB N1 VSS VSS nfet_03v3 L=0.5u W=10u nf=1 ad=8p as=8p pd=21.6u ps=21.6u m=1
X13 N1 CMPO VDD VDD pfet_03v3 L=0.5u W=2u nf=1 ad=1.6p as=1.6p pd=5.6u ps=5.6u m=1
X14 POR_RAW N1 VDD VDD pfet_03v3 L=0.5u W=2u nf=1 ad=1.6p as=1.6p pd=5.6u ps=5.6u m=1
X15 NA NA VDDA VDD pfet_03v3 L=1u W=4u nf=1 ad=3.2p as=3.2p pd=9.6u ps=9.6u m=1
X16 CMPO NA VDDA VDD pfet_03v3 L=1u W=4u nf=1 ad=3.2p as=3.2p pd=9.6u ps=9.6u m=1
X17 VDDA BIAS_OKB VDD VDD pfet_03v3 L=0.5u W=4u nf=1 ad=3.2p as=3.2p pd=9.6u ps=9.6u m=1
X18 BIAS_OKB BIAS_OK VDD VDD pfet_03v3 L=0.5u W=2u nf=1 ad=1.6p as=1p pd=5.6u ps=5u m=1
X19 SNS VDD VSS ppolyf_u_3k r_width=2u r_length=7897.44u
X20 SNSB SNS VSS ppolyf_u_3k r_width=2u r_length=6769.23u
X21 VSS SNSB VSS ppolyf_u_3k r_width=2u r_length=775u

R_10 SNS SNS__par 1410.6865
C_10 SNS__par VSS 2.5945833e-14
R_12 NBG NBG__par 1516.9554
C_12 NBG__par VSS 2.1326008e-14
R_14 SNSB SNSB__par 1330.8009
C_14 SNSB__par VSS 1.7531363e-14
R_3 VDDA VDDA__par 1263.8244
C_3 VDDA__par VSS 1.4679011e-14
R_4 NA NA__par 1384.846
C_4 NA__par VSS 1.5868526e-14
R_5 CMPO CMPO__par 1382.1249
C_5 CMPO__par VSS 1.7766709e-14
R_7 N1 N1__par 1437.8825
C_7 N1__par VSS 1.7866109e-14
R_9 TN TN__par 1261.1261
C_9 TN__par VSS 1.3588667e-14
RBIAS_OK BIAS_OK BIAS_OK__par 1452.1675
CBIAS_OK BIAS_OK__par VSS 1.5015489e-14
RBIAS_OKB BIAS_OKB BIAS_OKB__par 1631.1837
CBIAS_OKB BIAS_OKB__par VSS 2.1659338e-14
RIBIAS IBIAS IBIAS__par 1265.9835
CIBIAS IBIAS__par VSS 1.5551286e-14
RPOR_RAW POR_RAW POR_RAW__par 1260.5254
CPOR_RAW POR_RAW__par VSS 1.3389027e-14
RVDD VDD VDD__par 74.7605
CVDD VDD__par VSS 5.225586e-14
RVREF VREF VREF__par 1314.9134
CVREF VREF__par VSS 1.1576327e-14
RVSS VSS VSS__par 129.6781
CVSS VSS__par VSS 1.98907083e-13
.ends por_comparator

* por_output_chain -- post-layout netlist
* GENERATED by layout/postlayout.py -- do not edit.
*
* FROM THE LAYOUT: every device and its dimensions, the whole
*   topology, and first-order interconnect R/C on 18/30 nets
*   (sigma 828.6 fF). klt 0.2.0, deck gf180mcu,
*   GDS sha256 7929251a11eea645...
* Net names are the schematic's, restored through klt lvs's own net
*   correspondence -- match, 30/30 nets, every one paired.
*
* NOT FROM THE LAYOUT -- see layout/postlayout/AUDIT.md:
*   12 body/plate net(s) tied to the net the schematic puts
*   them on. The extraction deck's connectivity stack does not reach
*   an Nwell, a substrate ring, a bipolar base well or a MiM plate,
*   so they extract isolated and would otherwise float.
*   No ideal device: every golden device is drawn.
*
.subckt por_output_chain VDD VSS IBIAS POR_RAW RESETn

* --- drawn devices ---
X1 PDN IBIAS VSS VSS nfet_03v3 L=25u W=0.5u nf=1 ad=0.4p as=0.4p pd=2.6u ps=2.6u m=1
X2 PGDGB PGDG VSS VSS nfet_03v3 L=2u W=0.5u nf=1 ad=0.4p as=0.4p pd=2.6u ps=2.6u m=1
X3 ND1 NDL VSS VSS nfet_03v3 L=10u W=0.5u nf=1 ad=0.4p as=0.4p pd=2.6u ps=2.6u m=1
X4 NDG POR_RAW NDGN VSS nfet_03v3 L=0.5u W=1u nf=1 ad=0.8p as=0.8p pd=3.6u ps=3.6u m=1
X5 TIM PGDGB VSS VSS nfet_03v3 L=1u W=1u nf=1 ad=0.8p as=0.8p pd=3.6u ps=3.6u m=1
X6 TRIP ND1 VSS VSS nfet_03v3 L=1u W=1u nf=1 ad=0.8p as=0.8p pd=3.6u ps=3.6u m=1
X7 ND1 RESETn VSS VSS nfet_03v3 L=1u W=1u nf=1 ad=0.8p as=0.8p pd=3.6u ps=3.6u m=1
X8 NDL NDL VSS VSS nfet_03v3 L=10u W=2u nf=1 ad=1.6p as=1.6p pd=5.6u ps=5.6u m=1
X9 PGDG NDG VSS VSS nfet_03v3 L=0.5u W=2u nf=1 ad=1.6p as=1.6p pd=5.6u ps=5.6u m=1
X10 RSTB TRIP NNAND VSS nfet_03v3 L=0.5u W=2u nf=1 ad=1.6p as=1.6p pd=5.6u ps=5.6u m=1
X11 NNAND PGDG VSS VSS nfet_03v3 L=0.5u W=2u nf=1 ad=1.6p as=1.6p pd=5.6u ps=5.6u m=1
X12 IBIAS IBIAS VSS VSS nfet_03v3 L=4u W=4u nf=1 ad=3.2p as=3.2p pd=9.6u ps=9.6u m=1
X13 NDGN NDL VSS VSS nfet_03v3 L=10u W=10u nf=1 ad=8p as=8p pd=21.6u ps=21.6u m=1
X14 RESETn RSTB VSS VSS nfet_03v3 L=0.5u W=10u nf=1 ad=8p as=8p pd=21.6u ps=21.6u m=1
X15 NTS PDN VDD VDD pfet_03v3 L=10u W=0.5u nf=1 ad=0.4p as=0.4p pd=2.6u ps=2.6u m=1
X16 TRIP PDN VDD VDD pfet_03v3 L=10u W=0.5u nf=1 ad=0.4p as=0.4p pd=2.6u ps=2.6u m=1
X17 PGDG NDG VDD VDD pfet_03v3 L=2u W=0.5u nf=1 ad=0.4p as=0.4p pd=2.6u ps=2.6u m=1
X18 RSTB RESETn VDD VDD pfet_03v3 L=10u W=0.5u nf=1 ad=0.4p as=0.4p pd=2.6u ps=2.6u m=1
X19 NDG POR_RAW NDGP VDD pfet_03v3 L=0.5u W=1u nf=1 ad=0.8p as=0.8p pd=3.6u ps=3.6u m=1
X20 RESETn RSTB VDD VDD pfet_03v3 L=1u W=1u nf=1 ad=0.8p as=0.8p pd=3.6u ps=3.6u m=1
X21 PDN PDN VDD VDD pfet_03v3 L=10u W=2u nf=1 ad=1.6p as=1.6p pd=5.6u ps=5.6u m=1
X22 NDL PDN VDD VDD pfet_03v3 L=10u W=2u nf=1 ad=1.6p as=1.6p pd=5.6u ps=5.6u m=1
X23 PGDGB PGDG VDD VDD pfet_03v3 L=0.5u W=2u nf=1 ad=1.6p as=1.6p pd=5.6u ps=5.6u m=1
X24 TIM PGDGB NTS VDD pfet_03v3 L=1u W=2u nf=1 ad=1.6p as=1.6p pd=5.6u ps=5.6u m=1
X25 ND1 TIM VDD VDD pfet_03v3 L=1u W=2u nf=1 ad=1.6p as=1.6p pd=5.6u ps=5.6u m=1
X26 RSTB TRIP VDD VDD pfet_03v3 L=0.5u W=4u nf=1 ad=3.2p as=3.2p pd=9.6u ps=9.6u m=1
X27 RSTB PGDG VDD VDD pfet_03v3 L=0.5u W=4u nf=1 ad=3.2p as=3.2p pd=9.6u ps=9.6u m=1
X28 NDGP PDN VDD VDD pfet_03v3 L=10u W=10u nf=1 ad=8p as=8p pd=21.6u ps=21.6u m=1
X29 NDG VSS cap_mim_2f0_m3m4_noshield c_width=11u c_length=11u
X30 TIM VSS cap_mim_2f0_m3m4_noshield c_width=28u c_length=28u
X31 TIM VSS cap_mim_2f0_m3m4_noshield c_width=28u c_length=28u
X32 TIM VSS cap_mim_2f0_m3m4_noshield c_width=28u c_length=28u
X33 TIM VSS cap_mim_2f0_m3m4_noshield c_width=28u c_length=28u

R_10 PGDGB PGDGB__par 4066.8737
C_10 PGDGB__par VSS 3.8945287e-14
R_11 TIM TIM__par 4003.4777
C_11 TIM__par VSS 3.7210339e-14
R_12 ND1 ND1__par 4009.3517
C_12 ND1__par VSS 3.9540693e-14
R_13 TRIP TRIP__par 4060.1906
C_13 TRIP__par VSS 3.9480796e-14
R_14 NNAND NNAND__par 3939.9598
C_14 NNAND__par VSS 3.5425418e-14
R_15 NDGP NDGP__par 3936.7209
C_15 NDGP__par VSS 3.4117005e-14
R_16 NTS NTS__par 3938.5314
C_16 NTS__par VSS 3.4848444e-14
R_17 RSTB RSTB__par 4076.1772
C_17 RSTB__par VSS 4.4255369e-14
R_2 NDL NDL__par 4462.4943
C_2 NDL__par VSS 4.7374149e-14
R_6 PDN PDN__par 4872.4842
C_6 PDN__par VSS 5.6528747e-14
R_7 NDGN NDGN__par 3937.0807
C_7 NDGN__par VSS 3.4262384e-14
R_8 NDG NDG__par 4070.1194
C_8 NDG__par VSS 3.8582127e-14
R_9 PGDG PGDG__par 4189.4235
C_9 PGDG__par VSS 4.2346747e-14
RIBIAS IBIAS IBIAS__par 4398.6611
CIBIAS IBIAS__par VSS 4.5280553e-14
RPOR_RAW POR_RAW POR_RAW__par 4047.2842
CPOR_RAW POR_RAW__par VSS 3.435215e-14
RRESETn RESETn RESETn__par 4167.0798
CRESETn RESETn__par VSS 4.4306787e-14
RVDD VDD VDD__par 79.793
CVDD VDD__par VSS 6.9019152e-14
RVSS VSS VSS__par 66.6796
CVSS VSS__par VSS 1.12713456e-13
.ends por_output_chain
