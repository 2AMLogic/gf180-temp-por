* bias_core ramp-feedthrough control -- postlayout @ res_ss_27c_2.97v, tramp=16 ms -- GENERATED by run_ramp_feedthrough.py, do not edit
* pdk=gf180mcuD@c6d73a35f524070e85faff4a6a9eef49553ebc2b  harness=0.1.0

.param vdd_nom=3.3
.param vdd_val=2.97
.param temp_c=27.0
.param tramp=0.016

.include "/home/ubuntu/.volare/gf180mcuD/libs.tech/ngspice/design.ngspice"
.lib "/home/ubuntu/.volare/gf180mcuD/libs.tech/ngspice/sm141064.ngspice" typical
.lib "/home/ubuntu/.volare/gf180mcuD/libs.tech/ngspice/sm141064.ngspice" res_ss
.lib "/home/ubuntu/.volare/gf180mcuD/libs.tech/ngspice/sm141064.ngspice" bjt_typical
.lib "/home/ubuntu/.volare/gf180mcuD/libs.tech/ngspice/sm141064.ngspice" diode_typical
.lib "/home/ubuntu/.volare/gf180mcuD/libs.tech/ngspice/sm141064.ngspice" moscap_typical
.lib "/home/ubuntu/.volare/gf180mcuD/libs.tech/ngspice/sm141064.ngspice" mimcap_typical

.temp 27.0
.options reltol=1e-4
.options abstol=1e-15
.options vntol=1e-8

.include "../ramp_feedthrough.spice"
.include "../../../../layout/postlayout/bias_core.spice"

.control
set numdgt=10
set noaskquit
tran 5u 0.036000000000000004
meas tran vref_settle find v(vref) at=0.018900000000000004
meas tran vref_up find v(vref) when v(vdd)=2.50 rise=1
meas tran vref_dn find v(vref) when v(vdd)=2.55 fall=1
.endc
.end
