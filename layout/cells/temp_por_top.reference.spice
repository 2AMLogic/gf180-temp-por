* temp_por_top -- klt lvs reference netlist
* generated by layout/lvs_reference.py from design/netlist/temp_por_top.spice
* Do not edit: edit the schematic, re-run design/netlist.py, re-run this.
.SUBCKT temp_por_top VDD VSS PTAT CTAT RESETn
M1 xbias.NBG xbias.NBG VSS VSS nfet L=4U W=2U
M2 xbias.NA xbias.PG VDD VDD pfet L=4U W=8U
M3 xbias.NBTOP xbias.PG VDD VDD pfet L=4U W=8U
M4 VREF xbias.PG VDD VDD pfet L=4U W=8U
M5 xbias.NBG xbias.PG VDD VDD pfet L=4U W=2U
M6 xbias.PB xbias.PB VDD VDD pfet L=4U W=2U
M7 IBIAS xbias.PB VDD VDD pfet L=4U W=40U
M8 xbias.NT xbias.PB VDD VDD pfet L=4U W=2U
M9 xbias.N1 xbias.NA xbias.NT VDD pfet L=4U W=16U
M10 xbias.N2 xbias.NB xbias.NT VDD pfet L=4U W=16U
M11 xbias.PG xbias.PB VDD VDD pfet L=4U W=2U
M12 xbias.NKM xbias.PB VDD VDD pfet L=4U W=1U
M13 xbias.TOK xbias.PB VDD VDD pfet L=4U W=1U
M14 xbias.NOKO xbias.NA xbias.TOK VDD pfet L=4U W=8U
M15 xbias.NOKL xbias.NBTOP xbias.TOK VDD pfet L=4U W=8U
M16 xbias.NOKX xbias.PB VDD VDD pfet L=4U W=1U
M17 BIAS_OK xbias.NOKX VDD VDD pfet L=4U W=1U
M18 xbias.PB xbias.NBG VSS VSS nfet L=4U W=2U
M19 xbias.N1 xbias.N1 VSS VSS nfet L=8U W=4U
M20 xbias.N2 xbias.N1 VSS VSS nfet L=8U W=4U
M21 xbias.PG xbias.N2 VSS VSS nfet L=8U W=8U
M22 VDD VDD xbias.KS1 VSS nfet L=8U W=1U
M23 xbias.KS1 xbias.KS1 xbias.KS2 VSS nfet L=8U W=1U
M24 xbias.KS2 xbias.KS2 xbias.KS3 VSS nfet L=8U W=1U
M25 xbias.KS3 xbias.KS3 xbias.KS4 VSS nfet L=8U W=1U
M26 xbias.KS4 xbias.KS4 xbias.NKG VSS nfet L=8U W=1U
M27 xbias.NKM xbias.NKM VSS VSS nfet L=4U W=2U
M28 xbias.NKG xbias.NKM VSS VSS nfet L=4U W=8U
M29 xbias.PG xbias.NKG VSS VSS nfet L=4U W=1U
M30 xbias.NOKL xbias.NOKL VSS VSS nfet L=4U W=2U
M31 xbias.NOKO xbias.NOKL VSS VSS nfet L=4U W=2U
M32 xbias.NOKO xbias.NKG VSS VSS nfet L=1U W=2U
M33 xbias.NOKX xbias.NOKO VSS VSS nfet L=4U W=2U
M34 BIAS_OK xbias.NOKX VSS VSS nfet L=0.5U W=4U
R35 xbias.NBTOP xbias.XRT.1 VSS 4375 ppolyf_u_1k
R36 xbias.XRT.1 xbias.NB VSS 4375 ppolyf_u_1k
R37 xbias.NB xbias.XR1.1 VSS 87500 ppolyf_u_1k
R38 xbias.XR1.1 xbias.EC VSS 87500 ppolyf_u_1k
R39 VREF xbias.XR2.1 VSS 128250 ppolyf_u_1k
R40 xbias.XR2.1 xbias.XR2.2 VSS 128250 ppolyf_u_1k
R41 xbias.XR2.2 xbias.XR2.3 VSS 128250 ppolyf_u_1k
R42 xbias.XR2.3 xbias.XR2.4 VSS 128250 ppolyf_u_1k
R43 xbias.XR2.4 xbias.XR2.5 VSS 128250 ppolyf_u_1k
R44 xbias.XR2.5 xbias.XR2.6 VSS 128250 ppolyf_u_1k
R45 xbias.XR2.6 xbias.XR2.7 VSS 128250 ppolyf_u_1k
R46 xbias.XR2.7 xbias.XR2.8 VSS 128250 ppolyf_u_1k
R47 xbias.XR2.8 xbias.XR2.9 VSS 128250 ppolyf_u_1k
R48 xbias.XR2.9 xbias.XR2.10 VSS 128250 ppolyf_u_1k
R49 xbias.XR2.10 xbias.XR2.11 VSS 128250 ppolyf_u_1k
R50 xbias.XR2.11 xbias.XR2.12 VSS 128250 ppolyf_u_1k
R51 xbias.XR2.12 xbias.XR2.13 VSS 128250 ppolyf_u_1k
R52 xbias.XR2.13 xbias.XR2.14 VSS 128250 ppolyf_u_1k
R53 xbias.XR2.14 xbias.XR2.15 VSS 128250 ppolyf_u_1k
R54 xbias.XR2.15 xbias.ER VSS 128250 ppolyf_u_1k
R55 xbias.NZ xbias.XRZ.1 VSS 127000 ppolyf_u_1k
R56 xbias.XRZ.1 xbias.XRZ.2 VSS 127000 ppolyf_u_1k
R57 xbias.XRZ.2 xbias.XRZ.3 VSS 127000 ppolyf_u_1k
R58 xbias.XRZ.3 xbias.N2 VSS 127000 ppolyf_u_1k
Q59 VSS VSS xbias.NA bjt AE=100P
Q60 VSS VSS xbias.EC bjt AE=100P
Q61 VSS VSS xbias.EC bjt AE=100P
Q62 VSS VSS xbias.EC bjt AE=100P
Q63 VSS VSS xbias.EC bjt AE=100P
Q64 VSS VSS xbias.EC bjt AE=100P
Q65 VSS VSS xbias.EC bjt AE=100P
Q66 VSS VSS xbias.EC bjt AE=100P
Q67 VSS VSS xbias.EC bjt AE=100P
Q68 VSS VSS xbias.ER bjt AE=100P
C69 xbias.PG xbias.NZ 8.15064e-13 cap_mim_2f0_m4m5_noshield A=400P P=80U
C70 VDD xbias.NOKX 7.73592e-14 cap_mim_2f0_m4m5_noshield A=36P P=24U
M71 xcmp.BIAS_OKB BIAS_OK VSS VSS nfet L=0.5U W=1U
M72 xcmp.BIAS_OKB BIAS_OK VDD xcmp.NW2 pfet L=0.5U W=2U
M73 xcmp.NA xcmp.NA xcmp.VDDA VDD pfet L=1U W=4U
M74 xcmp.CMPO xcmp.NA xcmp.VDDA VDD pfet L=1U W=4U
M75 xcmp.VDDA xcmp.BIAS_OKB VDD VDD pfet L=0.5U W=4U
M76 xcmp.N1 xcmp.CMPO VDD VDD pfet L=0.5U W=2U
M77 POR_RAW xcmp.N1 VDD VDD pfet L=0.5U W=2U
M78 xcmp.NA xcmp.SNS xcmp.TN VSS nfet L=1U W=2U
M79 xcmp.CMPO VREF xcmp.TN VSS nfet L=1U W=2U
M80 xcmp.TN xcmp.NBG VSS VSS nfet L=10U W=1U
M81 IBIAS xcmp.NBG VSS VSS nfet L=2U W=2U
M82 IBIAS BIAS_OK xcmp.NBG VSS nfet L=0.5U W=2U
M83 xcmp.NBG xcmp.BIAS_OKB VSS VSS nfet L=0.5U W=2U
M84 IBIAS xcmp.BIAS_OKB VSS VSS nfet L=1U W=1U
M85 xcmp.SNSB xcmp.N1 VSS VSS nfet L=0.5U W=10U
M86 xcmp.CMPO xcmp.BIAS_OKB VSS VSS nfet L=1U W=2U
M87 xcmp.N1 xcmp.CMPO VSS VSS nfet L=0.5U W=1U
M88 POR_RAW xcmp.N1 VSS VSS nfet L=0.5U W=1U
R89 xcmp.SNS VDD VSS 3948720 ppolyf_u_1k
R90 xcmp.SNSB xcmp.SNS VSS 3384615 ppolyf_u_1k
R91 VSS xcmp.SNSB VSS 387500 ppolyf_u_1k
M92 IBIAS IBIAS VSS VSS nfet L=4U W=4U
M93 xpor.PDN xpor.PDN VDD VDD pfet L=10U W=2U
M94 xpor.PDN IBIAS VSS VSS nfet L=25U W=0.5U
M95 xpor.NDL xpor.NDL VSS VSS nfet L=10U W=2U
M96 xpor.NDGN xpor.NDL VSS VSS nfet L=10U W=10U
M97 xpor.NDG POR_RAW xpor.NDGN VSS nfet L=0.5U W=1U
M98 xpor.PGDG xpor.NDG VSS VSS nfet L=0.5U W=2U
M99 xpor.PGDGB xpor.PGDG VSS VSS nfet L=2U W=0.5U
M100 xpor.TIM xpor.PGDGB VSS VSS nfet L=1U W=1U
M101 xpor.ND1 xpor.NDL VSS VSS nfet L=10U W=0.5U
M102 xpor.TRIP xpor.ND1 VSS VSS nfet L=1U W=1U
M103 xpor.ND1 RESETn VSS VSS nfet L=1U W=1U
M104 xpor.RSTB xpor.TRIP xpor.NNAND VSS nfet L=0.5U W=2U
M105 xpor.NNAND xpor.PGDG VSS VSS nfet L=0.5U W=2U
M106 RESETn xpor.RSTB VSS VSS nfet L=0.5U W=10U
M107 xpor.NDL xpor.PDN VDD VDD pfet L=10U W=2U
M108 xpor.NDGP xpor.PDN VDD VDD pfet L=10U W=10U
M109 xpor.NTS xpor.PDN VDD VDD pfet L=10U W=0.5U
M110 xpor.TRIP xpor.PDN VDD VDD pfet L=10U W=0.5U
M111 xpor.NDG POR_RAW xpor.NDGP VDD pfet L=0.5U W=1U
M112 xpor.PGDG xpor.NDG VDD VDD pfet L=2U W=0.5U
M113 xpor.PGDGB xpor.PGDG VDD VDD pfet L=0.5U W=2U
M114 xpor.TIM xpor.PGDGB xpor.NTS VDD pfet L=1U W=2U
M115 xpor.ND1 xpor.TIM VDD VDD pfet L=1U W=2U
M116 xpor.RSTB xpor.TRIP VDD VDD pfet L=0.5U W=4U
M117 xpor.RSTB xpor.PGDG VDD VDD pfet L=0.5U W=4U
M118 xpor.RSTB RESETn VDD VDD pfet L=10U W=0.5U
M119 RESETn xpor.RSTB VDD VDD pfet L=1U W=1U
C120 xpor.NDG VSS 2.512752e-13 cap_mim_2f0_m4m5_noshield A=121P P=44U
C121 xpor.TIM VSS 1.5868496e-12 cap_mim_2f0_m4m5_noshield A=784P P=112U
C122 xpor.TIM VSS 1.5868496e-12 cap_mim_2f0_m4m5_noshield A=784P P=112U
C123 xpor.TIM VSS 1.5868496e-12 cap_mim_2f0_m4m5_noshield A=784P P=112U
C124 xpor.TIM VSS 1.5868496e-12 cap_mim_2f0_m4m5_noshield A=784P P=112U
M125 IBIAS xtemp.NBG VSS VSS nfet L=2U W=4U
M126 IBIAS RESETn xtemp.NBG VSS nfet L=0.5U W=2U
M127 xtemp.NBG xtemp.ENB VSS VSS nfet L=0.5U W=2U
M128 xtemp.PB xtemp.NBG VSS VSS nfet L=2U W=4U
M129 xtemp.PB xtemp.PB VDD xtemp.NW1 pfet L=4U W=10U
M130 xtemp.PCAS xtemp.NBG VSS VSS nfet L=2U W=4U
M131 xtemp.PCAS xtemp.PCAS VDD xtemp.NW1 pfet L=8U W=1U
M132 xtemp.ENB RESETn VDD xtemp.NW1 pfet L=0.5U W=2U
M133 xtemp.ENB RESETn VSS VSS nfet L=0.5U W=1U
M134 xtemp.NT xtemp.PB VDD xtemp.NW1 pfet L=4U W=20U
M135 xtemp.N1 xtemp.NA xtemp.NT xtemp.NW2 pfet L=4U W=16U
M136 xtemp.N1 xtemp.NA xtemp.NT xtemp.NW2 pfet L=4U W=16U
M137 xtemp.N2 xtemp.NB xtemp.NT xtemp.NW2 pfet L=4U W=16U
M138 xtemp.N2 xtemp.NB xtemp.NT xtemp.NW2 pfet L=4U W=16U
M139 xtemp.N1 xtemp.N1 VSS VSS nfet L=8U W=4U
M140 xtemp.N1 xtemp.N1 VSS VSS nfet L=8U W=4U
M141 xtemp.N2 xtemp.N1 VSS VSS nfet L=8U W=4U
M142 xtemp.N2 xtemp.N1 VSS VSS nfet L=8U W=4U
M143 xtemp.PG xtemp.N2 VSS VSS nfet L=8U W=8U
M144 xtemp.PG xtemp.PB VDD xtemp.NW1 pfet L=4U W=10U
M145 xtemp.M1D xtemp.PG VDD xtemp.NW1 pfet L=4U W=4U
M146 xtemp.M1D xtemp.PG VDD xtemp.NW1 pfet L=4U W=4U
M147 xtemp.NA xtemp.PCAS xtemp.M1D xtemp.NW1 pfet L=1U W=4U
M148 xtemp.NA xtemp.PCAS xtemp.M1D xtemp.NW1 pfet L=1U W=4U
M149 xtemp.M2D xtemp.PG VDD xtemp.NW1 pfet L=4U W=4U
M150 xtemp.M2D xtemp.PG VDD xtemp.NW1 pfet L=4U W=4U
M151 xtemp.NB xtemp.PCAS xtemp.M2D xtemp.NW1 pfet L=1U W=4U
M152 xtemp.NB xtemp.PCAS xtemp.M2D xtemp.NW1 pfet L=1U W=4U
M153 xtemp.M3D xtemp.PG VDD xtemp.NW1 pfet L=4U W=4U
M154 xtemp.M3D xtemp.PG VDD xtemp.NW1 pfet L=4U W=4U
M155 PTAT xtemp.PCAS xtemp.M3D xtemp.NW1 pfet L=1U W=4U
M156 PTAT xtemp.PCAS xtemp.M3D xtemp.NW1 pfet L=1U W=4U
M157 xtemp.ND xtemp.PB VDD xtemp.NW1 pfet L=8U W=1U
M158 xtemp.ND xtemp.NR VSS VSS nfet L=2U W=2U
M159 xtemp.PG xtemp.ND VSS VSS nfet L=1U W=4U
M160 xtemp.ND xtemp.ENB VSS VSS nfet L=0.5U W=2U
M161 xtemp.PG RESETn VDD xtemp.NW1 pfet L=0.5U W=4U
M162 PTAT xtemp.ENB VSS VSS nfet L=1U W=1U
M163 CTAT xtemp.ENB VSS VSS nfet L=1U W=1U
M164 xtemp.NR xtemp.PG VDD xtemp.NW1 pfet L=4U W=1U
M165 xtemp.NR xtemp.NR VSS VSS nfet L=2U W=2U
M166 xtemp.N2 xtemp.ENB VSS VSS nfet L=1U W=2U
M167 xtemp.NT xtemp.ENB VSS VSS nfet L=1U W=2U
M168 xtemp.T5 VDD xtemp.T4 VSS nfet L=0.5U W=32U
M169 xtemp.T4 VSS xtemp.T3 VSS nfet L=0.5U W=32U
M170 xtemp.T3 VSS xtemp.T2 VSS nfet L=0.5U W=32U
M171 xtemp.T2 VSS xtemp.T1 VSS nfet L=0.5U W=32U
M172 xtemp.T1 VSS xtemp.T0 VSS nfet L=0.5U W=32U
M173 xtemp.T0 VSS VSS VSS nfet L=0.5U W=32U
MD174 xtemp.NT xtemp.NT xtemp.NT xtemp.NW2 pfet L=4U W=16U
MD175 xtemp.NT xtemp.NT xtemp.NT xtemp.NW2 pfet L=4U W=16U
MD176 VSS VSS VSS VSS nfet L=8U W=4U
MD177 VSS VSS VSS VSS nfet L=8U W=4U
MD178 VDD VDD VDD xtemp.NW1 pfet L=4U W=4U
MD179 VDD VDD VDD xtemp.NW1 pfet L=4U W=4U
R180 xtemp.NB xtemp.XR1.1 VSS 10453.625 ppolyf_u
R181 xtemp.XR1.1 xtemp.NC VSS 10453.625 ppolyf_u
R182 xtemp.NA xtemp.XRISO.1 VSS 9716.875 ppolyf_u
R183 xtemp.XRISO.1 CTAT VSS 9716.875 ppolyf_u
R184 xtemp.NZ xtemp.XRZ.1 VSS 17500 ppolyf_u
R185 xtemp.XRZ.1 xtemp.XRZ.2 VSS 17500 ppolyf_u
R186 xtemp.XRZ.2 xtemp.XRZ.3 VSS 17500 ppolyf_u
R187 xtemp.XRZ.3 xtemp.XRZ.4 VSS 17500 ppolyf_u
R188 xtemp.XRZ.4 xtemp.XRZ.5 VSS 17500 ppolyf_u
R189 xtemp.XRZ.5 xtemp.XRZ.6 VSS 17500 ppolyf_u
R190 xtemp.XRZ.6 xtemp.XRZ.7 VSS 17500 ppolyf_u
R191 xtemp.XRZ.7 xtemp.XRZ.8 VSS 17500 ppolyf_u
R192 xtemp.XRZ.8 xtemp.XRZ.9 VSS 17500 ppolyf_u
R193 xtemp.XRZ.9 xtemp.N2 VSS 17500 ppolyf_u
R194 PTAT xtemp.XR2F.1 VSS 19341.875 ppolyf_u
R195 xtemp.XR2F.1 xtemp.XR2F.2 VSS 19341.875 ppolyf_u
R196 xtemp.XR2F.2 xtemp.XR2F.3 VSS 19341.875 ppolyf_u
R197 xtemp.XR2F.3 xtemp.XR2F.4 VSS 19341.875 ppolyf_u
R198 xtemp.XR2F.4 xtemp.XR2F.5 VSS 19341.875 ppolyf_u
R199 xtemp.XR2F.5 xtemp.XR2F.6 VSS 19341.875 ppolyf_u
R200 xtemp.XR2F.6 xtemp.XR2F.7 VSS 19341.875 ppolyf_u
R201 xtemp.XR2F.7 xtemp.XR2F.8 VSS 19341.875 ppolyf_u
R202 xtemp.XR2F.8 xtemp.XR2F.9 VSS 19341.875 ppolyf_u
R203 xtemp.XR2F.9 xtemp.XR2F.10 VSS 19341.875 ppolyf_u
R204 xtemp.XR2F.10 xtemp.XR2F.11 VSS 19341.875 ppolyf_u
R205 xtemp.XR2F.11 xtemp.XR2F.12 VSS 19341.875 ppolyf_u
R206 xtemp.XR2F.12 xtemp.XR2F.13 VSS 19341.875 ppolyf_u
R207 xtemp.XR2F.13 xtemp.XR2F.14 VSS 19341.875 ppolyf_u
R208 xtemp.XR2F.14 xtemp.XR2F.15 VSS 19341.875 ppolyf_u
R209 xtemp.XR2F.15 xtemp.XR2F.16 VSS 19341.875 ppolyf_u
R210 xtemp.XR2F.16 xtemp.XR2F.17 VSS 19341.875 ppolyf_u
R211 xtemp.XR2F.17 xtemp.XR2F.18 VSS 19341.875 ppolyf_u
R212 xtemp.XR2F.18 xtemp.XR2F.19 VSS 19341.875 ppolyf_u
R213 xtemp.XR2F.19 xtemp.XR2F.20 VSS 19341.875 ppolyf_u
R214 xtemp.XR2F.20 xtemp.XR2F.21 VSS 19341.875 ppolyf_u
R215 xtemp.XR2F.21 xtemp.XR2F.22 VSS 19341.875 ppolyf_u
R216 xtemp.XR2F.22 xtemp.XR2F.23 VSS 19341.875 ppolyf_u
R217 xtemp.XR2F.23 xtemp.T5 VSS 19341.875 ppolyf_u
R218 xtemp.T5 xtemp.XR2T5.1 VSS 20099.625 ppolyf_u
R219 xtemp.XR2T5.1 xtemp.T4 VSS 20099.625 ppolyf_u
R220 xtemp.T4 xtemp.XR2T4.1 VSS 10035.375 ppolyf_u
R221 xtemp.XR2T4.1 xtemp.T3 VSS 10035.375 ppolyf_u
R222 xtemp.T3 xtemp.XR2T3.1 VSS 5003.25 ppolyf_u
R223 xtemp.XR2T3.1 xtemp.T2 VSS 5003.25 ppolyf_u
R224 xtemp.T2 xtemp.XR2T2.1 VSS 2486.75 ppolyf_u
R225 xtemp.XR2T2.1 xtemp.T1 VSS 2486.75 ppolyf_u
R226 xtemp.T1 xtemp.XR2T1.1 VSS 1227.625 ppolyf_u
R227 xtemp.XR2T1.1 xtemp.T0 VSS 1227.625 ppolyf_u
R228 xtemp.T0 xtemp.XR2T0.1 VSS 599.375 ppolyf_u
R229 xtemp.XR2T0.1 VSS VSS 599.375 ppolyf_u
Q230 VSS VSS xtemp.NA bjt AE=100P
Q231 VSS VSS xtemp.NC bjt AE=100P
Q232 VSS VSS xtemp.NC bjt AE=100P
Q233 VSS VSS xtemp.NC bjt AE=100P
Q234 VSS VSS xtemp.NC bjt AE=100P
Q235 VSS VSS xtemp.NC bjt AE=100P
Q236 VSS VSS xtemp.NC bjt AE=100P
Q237 VSS VSS xtemp.NC bjt AE=100P
Q238 VSS VSS xtemp.NC bjt AE=100P
C239 xtemp.PG xtemp.NZ 2.979984e-13 cap_mim_2f0_m4m5_noshield A=144P P=48U
.ENDS temp_por_top
