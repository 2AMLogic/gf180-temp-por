* por-brownout-slew band-mechanism control @ ss / -40.0 C / 3.3 V / 3.4795 mV/us -- GENERATED by run_band_mechanism.py, do not edit
* pdk=gf180mcuD@c6d73a35f524070e85faff4a6a9eef49553ebc2b  harness=0.1.0

.param vdd_nom=3.3
.param vdd_val=3.3
.param temp_c=-40.0

.include "/Users/rwalters/.volare/gf180mcuD/libs.tech/ngspice/design.ngspice"
.lib "/Users/rwalters/.volare/gf180mcuD/libs.tech/ngspice/sm141064.ngspice" ss
.lib "/Users/rwalters/.volare/gf180mcuD/libs.tech/ngspice/sm141064.ngspice" res_ss
.lib "/Users/rwalters/.volare/gf180mcuD/libs.tech/ngspice/sm141064.ngspice" bjt_ss
.lib "/Users/rwalters/.volare/gf180mcuD/libs.tech/ngspice/sm141064.ngspice" diode_ss
.lib "/Users/rwalters/.volare/gf180mcuD/libs.tech/ngspice/sm141064.ngspice" moscap_ss
.lib "/Users/rwalters/.volare/gf180mcuD/libs.tech/ngspice/sm141064.ngspice" mimcap_ss

.temp -40.0
.options reltol=1e-4
.options abstol=1e-13
.options vntol=1e-8
.options method=gear

.param t_dip=0.02
.param t_edge=0.0006610145136
.param t_dwell=5e-05
.param t_margin=6e-05
.param dip_v=1.0

.include "../slew_dip.spice"
.include "../../../../design/netlist/temp_por_top.spice"

.control
set numdgt=8
set noaskquit
tran 2e-05 0.02143202903 0 5e-06
let bok_r = v(xdut.bias_ok)/(v(vdd)+0.001)
let praw_r = v(xdut.por_raw)/(v(vdd)+0.001)
let rst_r = v(resetn)/(v(vdd)+0.001)
let pgdg_r = v(xdut.xpor.pgdg)/(v(vdd)+0.001)
let ndg_r = v(xdut.xpor.ndg)/(v(vdd)+0.001)
let vsg = v(vdd)-v(xdut.xbias.pg)

meas tran vdd_pre find v(vdd) at=0.0199
meas tran rst_pre find v(resetn) at=0.0199
meas tran vsg_pre find vsg at=0.0199
meas tran t_vpor when v(vdd)=2.22 fall=1 td=0.02
meas tran t_praw when praw_r=0.5 fall=1 td=0.02
meas tran vdd_at_praw find v(vdd) when praw_r=0.5 fall=1 td=0.02
meas tran vsg_at_praw find vsg when praw_r=0.5 fall=1 td=0.02
meas tran t_pgdg when pgdg_r=0.5 fall=1 td=0.02
meas tran t_rst when rst_r=0.1 fall=1 td=0.02
meas tran vdd_at_rst find v(vdd) when rst_r=0.1 fall=1 td=0.02
meas tran t_bok when bok_r=0.5 fall=1 td=0.02
meas tran praw_r_min min praw_r from=0.02 to=0.02071101451
meas tran rst_r_min min rst_r from=0.02 to=0.02071101451
meas tran bok_r_min min bok_r from=0.02 to=0.02071101451
meas tran vsg_min min vsg from=0.02 to=0.02071101451
meas tran ndg_r_max max ndg_r from=0.02 to=0.02071101451
meas tran ndg_r_close find ndg_r at=0.02071101451
meas tran pgdg_r_min min pgdg_r from=0.02 to=0.02071101451
meas tran rst_r_min_overall min rst_r from=0.02 to=0.02143202903
.endc
.end
