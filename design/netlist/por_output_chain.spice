* por_output_chain -- generated by design/netlist.py from design/por_output_chain.sch
* Do not edit: edit the schematic and re-run the export.
** sch_path: design/por_output_chain.sch
.subckt por_output_chain VDD VSS IBIAS POR_RAW RESETn
*.PININFO VDD:B VSS:B IBIAS:I POR_RAW:I RESETn:O
Rplaceholder_resetn RESETn VSS 1T m=1
**** begin user architecture code

* PLACEHOLDER: por_output_chain has no internals yet -- they land with issue #12.
* The Rplaceholder_* devices in this cell are 1 Tohm terminations, not
* design content: they exist only so this stub is ERC-clean and DC-solvable.
* Nothing in this cell may be cited as simulation evidence.

**** end user architecture code
.ends
