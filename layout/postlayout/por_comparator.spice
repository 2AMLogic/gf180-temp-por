* por_comparator -- post-layout netlist
* GENERATED by layout/postlayout.py -- do not edit.
*
* FROM THE LAYOUT: every device and its dimensions, the whole
*   topology, and first-order interconnect R/C on 15/18 nets
*   (sigma 472.9 fF). klt 0.2.0, deck gf180mcu,
*   GDS sha256 c60a2ef35e34d6d4...
* Net names are the schematic's, restored through klt lvs's own net
*   correspondence -- match, 18/18 nets, every one paired.
*
* NOT FROM THE LAYOUT -- see layout/postlayout/AUDIT.md:
*   3 body/plate net(s) tied to the net the schematic puts
*   them on. The extraction deck's connectivity stack does not reach
*   an Nwell, a substrate ring, a bipolar base well or a MiM plate,
*   so they extract isolated and would otherwise float.
*   No ideal device: every golden device is drawn.
*
.subckt por_comparator VDD VSS IBIAS VREF BIAS_OK POR_RAW

* --- drawn devices ---
X1 TN NBG VSS VSS nfet_03v3 L=10u W=1u nf=1 ad=0.8p as=0.8p pd=3.6u ps=3.6u m=1
X2 IBIAS BIAS_OKB VSS VSS nfet_03v3 L=1u W=1u nf=1 ad=0.8p as=0.8p pd=3.6u ps=3.6u m=1
X3 N1 CMPO VSS VSS nfet_03v3 L=0.5u W=1u nf=1 ad=0.8p as=0.8p pd=3.6u ps=3.6u m=1
X4 POR_RAW N1 VSS VSS nfet_03v3 L=0.5u W=1u nf=1 ad=0.8p as=0.8p pd=3.6u ps=3.6u m=1
X5 BIAS_OKB BIAS_OK VSS VSS nfet_03v3 L=0.5u W=1u nf=1 ad=0.8p as=0.5p pd=3.6u ps=3u m=1
X6 NA SNS TN VSS nfet_03v3 L=1u W=2u nf=1 ad=1.6p as=1.6p pd=5.6u ps=5.6u m=1
X7 CMPO VREF TN VSS nfet_03v3 L=1u W=2u nf=1 ad=1.6p as=1.6p pd=5.6u ps=5.6u m=1
X8 IBIAS NBG VSS VSS nfet_03v3 L=2u W=2u nf=1 ad=1.6p as=1.6p pd=5.6u ps=5.6u m=1
X9 IBIAS BIAS_OK NBG VSS nfet_03v3 L=0.5u W=2u nf=1 ad=1.6p as=1.6p pd=5.6u ps=5.6u m=1
X10 NBG BIAS_OKB VSS VSS nfet_03v3 L=0.5u W=2u nf=1 ad=1.6p as=1.6p pd=5.6u ps=5.6u m=1
X11 CMPO BIAS_OKB VSS VSS nfet_03v3 L=1u W=2u nf=1 ad=1.6p as=1.6p pd=5.6u ps=5.6u m=1
X12 SNSB N1 VSS VSS nfet_03v3 L=0.5u W=10u nf=1 ad=8p as=8p pd=21.6u ps=21.6u m=1
X13 N1 CMPO VDD VDD pfet_03v3 L=0.5u W=2u nf=1 ad=1.6p as=1.6p pd=5.6u ps=5.6u m=1
X14 POR_RAW N1 VDD VDD pfet_03v3 L=0.5u W=2u nf=1 ad=1.6p as=1.6p pd=5.6u ps=5.6u m=1
X15 NA NA VDDA VDD pfet_03v3 L=1u W=4u nf=1 ad=3.2p as=3.2p pd=9.6u ps=9.6u m=1
X16 CMPO NA VDDA VDD pfet_03v3 L=1u W=4u nf=1 ad=3.2p as=3.2p pd=9.6u ps=9.6u m=1
X17 VDDA BIAS_OKB VDD VDD pfet_03v3 L=0.5u W=4u nf=1 ad=3.2p as=3.2p pd=9.6u ps=9.6u m=1
X18 BIAS_OKB BIAS_OK VDD VDD pfet_03v3 L=0.5u W=2u nf=1 ad=1.6p as=1p pd=5.6u ps=5u m=1
X19 SNS VDD VSS ppolyf_u_3k r_width=2u r_length=7897.44u
X20 SNSB SNS VSS ppolyf_u_3k r_width=2u r_length=6769.23u
X21 VSS SNSB VSS ppolyf_u_3k r_width=2u r_length=775u

R_10 SNS SNS__par 1410.6865
C_10 SNS__par VSS 2.5945833e-14
R_12 NBG NBG__par 1516.9554
C_12 NBG__par VSS 2.1326008e-14
R_14 SNSB SNSB__par 1330.8009
C_14 SNSB__par VSS 1.7531363e-14
R_3 VDDA VDDA__par 1263.8244
C_3 VDDA__par VSS 1.4679011e-14
R_4 NA NA__par 1384.846
C_4 NA__par VSS 1.5868526e-14
R_5 CMPO CMPO__par 1382.1249
C_5 CMPO__par VSS 1.7766709e-14
R_7 N1 N1__par 1437.8825
C_7 N1__par VSS 1.7866109e-14
R_9 TN TN__par 1261.1261
C_9 TN__par VSS 1.3588667e-14
RBIAS_OK BIAS_OK BIAS_OK__par 1452.1675
CBIAS_OK BIAS_OK__par VSS 1.5015489e-14
RBIAS_OKB BIAS_OKB BIAS_OKB__par 1631.1837
CBIAS_OKB BIAS_OKB__par VSS 2.1659338e-14
RIBIAS IBIAS IBIAS__par 1265.9835
CIBIAS IBIAS__par VSS 1.5551286e-14
RPOR_RAW POR_RAW POR_RAW__par 1260.5254
CPOR_RAW POR_RAW__par VSS 1.3389027e-14
RVDD VDD VDD__par 74.7605
CVDD VDD__par VSS 5.225586e-14
RVREF VREF VREF__par 1314.9134
CVREF VREF__par VSS 1.1576327e-14
RVSS VSS VSS__par 129.6781
CVSS VSS__par VSS 1.98907083e-13
.ends por_comparator
