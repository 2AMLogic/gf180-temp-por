* Frozen netlist snapshot for record 20260801-073944-8b7e57f
* source     : sim/temp-core-startup/testbench/tb_temp_core_startup.spice
* sha256     : 72e223383f9a35d153e2fac290a0919d6542b92277ac41aee34ca62eb49cdf30
* This is a verbatim copy taken at record time. Do not edit.
* tb_temp_core_startup -- GENERATED by sim/build_tb.py
* Do not edit. Sources:
*   sim/temp-core-startup/testbench/stimulus.spice
*   design/netlist/temp_core.spice  (sha256 c017e15399812a21ff04ac037d785e3c6b1fa77b5b0c45080fcacf6b9a5e64d4)
* Regenerate with:
*   python3 sim/build_tb.py

* temp-core-startup -- stimulus half of the testbench fragment.
*
* The other half is a verbatim copy of design/netlist/temp_core.spice,
* appended by sim/build_tb.py to produce tb_temp_core_startup.spice. Edit
* THIS file (or the schematic), never the generated fragment.
*
* Netlist FRAGMENT: no .include / .lib / .temp / .control / .end -- the
* harness owns those. Parameters it supplies: vdd_val, vdd_nom, temp_c.
*
* WHY THIS EXPERIMENT EXISTS
*
* A DVBE loop has a degenerate zero-current solution as well as its intended
* one, and an operating-point sweep only tells you which solution the solver
* happened to land on -- not which one silicon will sit in after a cold start
* or a brownout. The first revision of this cell used an absolute-level
* startup detector (a big NMOS with its gate on the 1x PNP's VEB) and the
* sim/temp-core-designer-check op grid caught it sitting in the dead state at
* fs/-40 C and at both resistor corners. design/temp_core.sch now uses a
* CURRENT-referenced detector instead; this testbench is the evidence that it
* actually starts, from 0 V, at every PVT point, and restarts after the rail
* collapses.
*
* TIMELINE (single DUT, driven exactly the way the top level drives it)
*
*   0     -> 1.0 ms   VDD ramps 0 -> vdd_val
*   0     -> 1.5 ms   EN low. This is the pre-POR window: RESETn is asserted,
*                     so the sensor is held off (DR-005 startup ordering,
*                     step 6). Nothing here may draw current.
*   1.4 ms            sample: pre-enable PTAT level and supply current
*   1.5 ms            EN released -- models RESETn deasserting
*   2.4 ms            sample 1: PTAT/CTAT after a cold start from 0 V
*   2.5 ms            EN pulled low, then VDD collapses to 0 by 2.6 ms
*                     (brownout: POR re-asserts before the rail goes)
*   3.0 -> 3.5 ms     VDD ramps back up
*   4.0 ms            EN released again
*   4.9 ms            sample 2: PTAT/CTAT after the restart
*
* sample 2 == sample 1 is the load-bearing check: if the loop can latch into
* its dead state, the restart is where it does it, and the two samples
* diverge instead of agreeing to a few hundred ppm.

vsup vdd 0 PWL(0 0 1m {vdd_val} 2.5m {vdd_val} 2.6m 0 3.0m 0 3.5m {vdd_val} 5m {vdd_val})
ven  en  0 PWL(0 0 1.5m 0 1.501m {vdd_val} 2.5m {vdd_val} 2.501m 0 4.0m 0 4.001m {vdd_val} 5m {vdd_val})

* IBIAS: bias_core's 0.5 uA reference, modelled as coming up with the rail
* rather than as an ideal DC source. Below ~1.5 V there is no bias core yet
* (DR-005 startup ordering, step 3), so forcing 0.5 uA into the pin while the
* rail is dead would be a stimulus artefact, not a startup test.
*
* vib is a 0 V ammeter. It has to be here: the reference is sourced from the
* same rail vsup meters, so that 0.5 uA shows up in i(vsup) even though it is
* bias_core's current, not temp_core's. Metering it separately is what lets
* the pre-POR check be about the cell's OWN draw.
*
* xmsh is load-bearing since DR-010. temp_core no longer clamps its IBIAS pin
* when disabled -- the pin is HIGH-Z, because IBIAS is a shared net and
* clamping it locked POR up (spec/decision-records/DR-010-*.md). The shared
* node therefore has to be defined by something OTHER than the DUT, exactly
* as it is in design/netlist/temp_por_top.spice: xmsh is a diode-connected
* nfet_03v3 4u/4u, a copy of por_output_chain's always-on XMBD, the element
* that actually holds that node at a diode drop in the assembled block.
* Without it the pre-POR window would be an ideal current source driving an
* open circuit -- the stimulus artefact the deleted clamp existed to paper
* over, and never a condition the block can be in.
*
* vibd meters what the DUT itself takes out of that node, which is the DR-010
* high-impedance invariant measured through the whole cold-start sequence
* rather than only at an operating point.
Bib vdd nib i='500n*min(1, max(0, (v(vdd)-1.5)/0.5))'
vib nib ibias dc 0
xmsh ibias ibias 0 0 nfet_03v3 L=4u W=4u nf=1 m=1
vibd ibias nibd dc 0

* Pads: 1 pF of pad/probe capacitance, otherwise unloaded (the cell has no
* output buffer -- see design/temp_core.md).
Cpp ptat 0 1p
Cpc ctat 0 1p
Rlp ptat 0 1T
Rlc ctat 0 1T

xdut vdd 0 nibd en ptat ctat temp_core

* temp_core -- generated by design/netlist.py from design/temp_core.sch
* Do not edit: edit the schematic and re-run the export.
** sch_path: design/temp_core.sch
.subckt temp_core VDD VSS IBIAS EN PTAT CTAT
*.PININFO VDD:B VSS:B IBIAS:I EN:I PTAT:O CTAT:O
XMBD IBIAS NBG VSS VSS nfet_03v3 L=2u W=4u nf=1 ad='int((nf+1)/2) * W/nf * 0.18u' as='int((nf+2)/2) * W/nf * 0.18u' pd='2*int((nf+1)/2) * (W/nf + 0.18u)'
+ ps='2*int((nf+2)/2) * (W/nf + 0.18u)' nrd='0.18u / W' nrs='0.18u / W' sa=0 sb=0 sd=0 m=1
XMPASS IBIAS EN NBG VSS nfet_03v3 L=0.5u W=2u nf=1 ad='int((nf+1)/2) * W/nf * 0.18u' as='int((nf+2)/2) * W/nf * 0.18u' pd='2*int((nf+1)/2) * (W/nf + 0.18u)'
+ ps='2*int((nf+2)/2) * (W/nf + 0.18u)' nrd='0.18u / W' nrs='0.18u / W' sa=0 sb=0 sd=0 m=1
XMDNB NBG ENB VSS VSS nfet_03v3 L=0.5u W=2u nf=1 ad='int((nf+1)/2) * W/nf * 0.18u' as='int((nf+2)/2) * W/nf * 0.18u' pd='2*int((nf+1)/2) * (W/nf + 0.18u)'
+ ps='2*int((nf+2)/2) * (W/nf + 0.18u)' nrd='0.18u / W' nrs='0.18u / W' sa=0 sb=0 sd=0 m=1
XMBN1 PB NBG VSS VSS nfet_03v3 L=2u W=4u nf=1 ad='int((nf+1)/2) * W/nf * 0.18u' as='int((nf+2)/2) * W/nf * 0.18u' pd='2*int((nf+1)/2) * (W/nf + 0.18u)'
+ ps='2*int((nf+2)/2) * (W/nf + 0.18u)' nrd='0.18u / W' nrs='0.18u / W' sa=0 sb=0 sd=0 m=1
XMBP PB PB VDD VDD pfet_03v3 L=4u W=10u nf=1 ad='int((nf+1)/2) * W/nf * 0.18u' as='int((nf+2)/2) * W/nf * 0.18u' pd='2*int((nf+1)/2) * (W/nf + 0.18u)'
+ ps='2*int((nf+2)/2) * (W/nf + 0.18u)' nrd='0.18u / W' nrs='0.18u / W' sa=0 sb=0 sd=0 m=1
XMBN2 PCAS NBG VSS VSS nfet_03v3 L=2u W=4u nf=1 ad='int((nf+1)/2) * W/nf * 0.18u' as='int((nf+2)/2) * W/nf * 0.18u' pd='2*int((nf+1)/2) * (W/nf + 0.18u)'
+ ps='2*int((nf+2)/2) * (W/nf + 0.18u)' nrd='0.18u / W' nrs='0.18u / W' sa=0 sb=0 sd=0 m=1
XMCB PCAS PCAS VDD VDD pfet_03v3 L=8u W=1u nf=1 ad='int((nf+1)/2) * W/nf * 0.18u' as='int((nf+2)/2) * W/nf * 0.18u' pd='2*int((nf+1)/2) * (W/nf + 0.18u)'
+ ps='2*int((nf+2)/2) * (W/nf + 0.18u)' nrd='0.18u / W' nrs='0.18u / W' sa=0 sb=0 sd=0 m=1
XMINVP ENB EN VDD VDD pfet_03v3 L=0.5u W=2u nf=1 ad='int((nf+1)/2) * W/nf * 0.18u' as='int((nf+2)/2) * W/nf * 0.18u' pd='2*int((nf+1)/2) * (W/nf + 0.18u)'
+ ps='2*int((nf+2)/2) * (W/nf + 0.18u)' nrd='0.18u / W' nrs='0.18u / W' sa=0 sb=0 sd=0 m=1
XMINVN ENB EN VSS VSS nfet_03v3 L=0.5u W=1u nf=1 ad='int((nf+1)/2) * W/nf * 0.18u' as='int((nf+2)/2) * W/nf * 0.18u' pd='2*int((nf+1)/2) * (W/nf + 0.18u)'
+ ps='2*int((nf+2)/2) * (W/nf + 0.18u)' nrd='0.18u / W' nrs='0.18u / W' sa=0 sb=0 sd=0 m=1
XMT NT PB VDD VDD pfet_03v3 L=4u W=20u nf=1 ad='int((nf+1)/2) * W/nf * 0.18u' as='int((nf+2)/2) * W/nf * 0.18u' pd='2*int((nf+1)/2) * (W/nf + 0.18u)'
+ ps='2*int((nf+2)/2) * (W/nf + 0.18u)' nrd='0.18u / W' nrs='0.18u / W' sa=0 sb=0 sd=0 m=1
XMI1 N1 NA NT NT pfet_03v3 L=4u W=32u nf=1 ad='int((nf+1)/2) * W/nf * 0.18u' as='int((nf+2)/2) * W/nf * 0.18u' pd='2*int((nf+1)/2) * (W/nf + 0.18u)'
+ ps='2*int((nf+2)/2) * (W/nf + 0.18u)' nrd='0.18u / W' nrs='0.18u / W' sa=0 sb=0 sd=0 m=1
XMI2 N2 NB NT NT pfet_03v3 L=4u W=32u nf=1 ad='int((nf+1)/2) * W/nf * 0.18u' as='int((nf+2)/2) * W/nf * 0.18u' pd='2*int((nf+1)/2) * (W/nf + 0.18u)'
+ ps='2*int((nf+2)/2) * (W/nf + 0.18u)' nrd='0.18u / W' nrs='0.18u / W' sa=0 sb=0 sd=0 m=1
XML1 N1 N1 VSS VSS nfet_03v3 L=8u W=8u nf=1 ad='int((nf+1)/2) * W/nf * 0.18u' as='int((nf+2)/2) * W/nf * 0.18u' pd='2*int((nf+1)/2) * (W/nf + 0.18u)'
+ ps='2*int((nf+2)/2) * (W/nf + 0.18u)' nrd='0.18u / W' nrs='0.18u / W' sa=0 sb=0 sd=0 m=1
XML2 N2 N1 VSS VSS nfet_03v3 L=8u W=8u nf=1 ad='int((nf+1)/2) * W/nf * 0.18u' as='int((nf+2)/2) * W/nf * 0.18u' pd='2*int((nf+1)/2) * (W/nf + 0.18u)'
+ ps='2*int((nf+2)/2) * (W/nf + 0.18u)' nrd='0.18u / W' nrs='0.18u / W' sa=0 sb=0 sd=0 m=1
XMS2N PG N2 VSS VSS nfet_03v3 L=8u W=8u nf=1 ad='int((nf+1)/2) * W/nf * 0.18u' as='int((nf+2)/2) * W/nf * 0.18u' pd='2*int((nf+1)/2) * (W/nf + 0.18u)'
+ ps='2*int((nf+2)/2) * (W/nf + 0.18u)' nrd='0.18u / W' nrs='0.18u / W' sa=0 sb=0 sd=0 m=1
XMS2P PG PB VDD VDD pfet_03v3 L=4u W=10u nf=1 ad='int((nf+1)/2) * W/nf * 0.18u' as='int((nf+2)/2) * W/nf * 0.18u' pd='2*int((nf+1)/2) * (W/nf + 0.18u)'
+ ps='2*int((nf+2)/2) * (W/nf + 0.18u)' nrd='0.18u / W' nrs='0.18u / W' sa=0 sb=0 sd=0 m=1
XCC PG NZ cap_mim_2f0_m3m4_noshield c_width=12u c_length=12u m=1
XRZ NZ N2 VSS ppolyf_u r_width=2u r_length=1000u m=1
XMP1 M1D PG VDD VDD pfet_03v3 L=4u W=8u nf=1 ad='int((nf+1)/2) * W/nf * 0.18u' as='int((nf+2)/2) * W/nf * 0.18u' pd='2*int((nf+1)/2) * (W/nf + 0.18u)'
+ ps='2*int((nf+2)/2) * (W/nf + 0.18u)' nrd='0.18u / W' nrs='0.18u / W' sa=0 sb=0 sd=0 m=1
XMPC1 NA PCAS M1D VDD pfet_03v3 L=1u W=8u nf=1 ad='int((nf+1)/2) * W/nf * 0.18u' as='int((nf+2)/2) * W/nf * 0.18u' pd='2*int((nf+1)/2) * (W/nf + 0.18u)'
+ ps='2*int((nf+2)/2) * (W/nf + 0.18u)' nrd='0.18u / W' nrs='0.18u / W' sa=0 sb=0 sd=0 m=1
XMP2 M2D PG VDD VDD pfet_03v3 L=4u W=8u nf=1 ad='int((nf+1)/2) * W/nf * 0.18u' as='int((nf+2)/2) * W/nf * 0.18u' pd='2*int((nf+1)/2) * (W/nf + 0.18u)'
+ ps='2*int((nf+2)/2) * (W/nf + 0.18u)' nrd='0.18u / W' nrs='0.18u / W' sa=0 sb=0 sd=0 m=1
XMPC2 NB PCAS M2D VDD pfet_03v3 L=1u W=8u nf=1 ad='int((nf+1)/2) * W/nf * 0.18u' as='int((nf+2)/2) * W/nf * 0.18u' pd='2*int((nf+1)/2) * (W/nf + 0.18u)'
+ ps='2*int((nf+2)/2) * (W/nf + 0.18u)' nrd='0.18u / W' nrs='0.18u / W' sa=0 sb=0 sd=0 m=1
XMP3 M3D PG VDD VDD pfet_03v3 L=4u W=8u nf=1 ad='int((nf+1)/2) * W/nf * 0.18u' as='int((nf+2)/2) * W/nf * 0.18u' pd='2*int((nf+1)/2) * (W/nf + 0.18u)'
+ ps='2*int((nf+2)/2) * (W/nf + 0.18u)' nrd='0.18u / W' nrs='0.18u / W' sa=0 sb=0 sd=0 m=1
XMPC3 PTAT PCAS M3D VDD pfet_03v3 L=1u W=8u nf=1 ad='int((nf+1)/2) * W/nf * 0.18u' as='int((nf+2)/2) * W/nf * 0.18u' pd='2*int((nf+1)/2) * (W/nf + 0.18u)'
+ ps='2*int((nf+2)/2) * (W/nf + 0.18u)' nrd='0.18u / W' nrs='0.18u / W' sa=0 sb=0 sd=0 m=1
XMSU1 ND PB VDD VDD pfet_03v3 L=8u W=1u nf=1 ad='int((nf+1)/2) * W/nf * 0.18u' as='int((nf+2)/2) * W/nf * 0.18u' pd='2*int((nf+1)/2) * (W/nf + 0.18u)'
+ ps='2*int((nf+2)/2) * (W/nf + 0.18u)' nrd='0.18u / W' nrs='0.18u / W' sa=0 sb=0 sd=0 m=1
XMSU2 ND NR VSS VSS nfet_03v3 L=2u W=2u nf=1 ad='int((nf+1)/2) * W/nf * 0.18u' as='int((nf+2)/2) * W/nf * 0.18u' pd='2*int((nf+1)/2) * (W/nf + 0.18u)'
+ ps='2*int((nf+2)/2) * (W/nf + 0.18u)' nrd='0.18u / W' nrs='0.18u / W' sa=0 sb=0 sd=0 m=1
XMSU3 PG ND VSS VSS nfet_03v3 L=1u W=4u nf=1 ad='int((nf+1)/2) * W/nf * 0.18u' as='int((nf+2)/2) * W/nf * 0.18u' pd='2*int((nf+1)/2) * (W/nf + 0.18u)'
+ ps='2*int((nf+2)/2) * (W/nf + 0.18u)' nrd='0.18u / W' nrs='0.18u / W' sa=0 sb=0 sd=0 m=1
XMDND ND ENB VSS VSS nfet_03v3 L=0.5u W=2u nf=1 ad='int((nf+1)/2) * W/nf * 0.18u' as='int((nf+2)/2) * W/nf * 0.18u' pd='2*int((nf+1)/2) * (W/nf + 0.18u)'
+ ps='2*int((nf+2)/2) * (W/nf + 0.18u)' nrd='0.18u / W' nrs='0.18u / W' sa=0 sb=0 sd=0 m=1
XMENPG PG EN VDD VDD pfet_03v3 L=0.5u W=4u nf=1 ad='int((nf+1)/2) * W/nf * 0.18u' as='int((nf+2)/2) * W/nf * 0.18u' pd='2*int((nf+1)/2) * (W/nf + 0.18u)'
+ ps='2*int((nf+2)/2) * (W/nf + 0.18u)' nrd='0.18u / W' nrs='0.18u / W' sa=0 sb=0 sd=0 m=1
XMENPT PTAT ENB VSS VSS nfet_03v3 L=1u W=1u nf=1 ad='int((nf+1)/2) * W/nf * 0.18u' as='int((nf+2)/2) * W/nf * 0.18u' pd='2*int((nf+1)/2) * (W/nf + 0.18u)'
+ ps='2*int((nf+2)/2) * (W/nf + 0.18u)' nrd='0.18u / W' nrs='0.18u / W' sa=0 sb=0 sd=0 m=1
XMENCT CTAT ENB VSS VSS nfet_03v3 L=1u W=1u nf=1 ad='int((nf+1)/2) * W/nf * 0.18u' as='int((nf+2)/2) * W/nf * 0.18u' pd='2*int((nf+1)/2) * (W/nf + 0.18u)'
+ ps='2*int((nf+2)/2) * (W/nf + 0.18u)' nrd='0.18u / W' nrs='0.18u / W' sa=0 sb=0 sd=0 m=1
XMSU4 NR PG VDD VDD pfet_03v3 L=4u W=1u nf=1 ad='int((nf+1)/2) * W/nf * 0.18u' as='int((nf+2)/2) * W/nf * 0.18u' pd='2*int((nf+1)/2) * (W/nf + 0.18u)'
+ ps='2*int((nf+2)/2) * (W/nf + 0.18u)' nrd='0.18u / W' nrs='0.18u / W' sa=0 sb=0 sd=0 m=1
XMSU5 NR NR VSS VSS nfet_03v3 L=2u W=2u nf=1 ad='int((nf+1)/2) * W/nf * 0.18u' as='int((nf+2)/2) * W/nf * 0.18u' pd='2*int((nf+1)/2) * (W/nf + 0.18u)'
+ ps='2*int((nf+2)/2) * (W/nf + 0.18u)' nrd='0.18u / W' nrs='0.18u / W' sa=0 sb=0 sd=0 m=1
XMDN2 N2 ENB VSS VSS nfet_03v3 L=1u W=2u nf=1 ad='int((nf+1)/2) * W/nf * 0.18u' as='int((nf+2)/2) * W/nf * 0.18u' pd='2*int((nf+1)/2) * (W/nf + 0.18u)'
+ ps='2*int((nf+2)/2) * (W/nf + 0.18u)' nrd='0.18u / W' nrs='0.18u / W' sa=0 sb=0 sd=0 m=1
XMDNT NT ENB VSS VSS nfet_03v3 L=1u W=2u nf=1 ad='int((nf+1)/2) * W/nf * 0.18u' as='int((nf+2)/2) * W/nf * 0.18u' pd='2*int((nf+1)/2) * (W/nf + 0.18u)'
+ ps='2*int((nf+2)/2) * (W/nf + 0.18u)' nrd='0.18u / W' nrs='0.18u / W' sa=0 sb=0 sd=0 m=1
XQ1 VSS VSS NA pnp_10p00x10p00 m=1
XQ8A VSS VSS NC pnp_10p00x10p00 m=1
XQ8B VSS VSS NC pnp_10p00x10p00 m=1
XQ8C VSS VSS NC pnp_10p00x10p00 m=1
XQ8D VSS VSS NC pnp_10p00x10p00 m=1
XQ8E VSS VSS NC pnp_10p00x10p00 m=1
XQ8F VSS VSS NC pnp_10p00x10p00 m=1
XQ8G VSS VSS NC pnp_10p00x10p00 m=1
XQ8H VSS VSS NC pnp_10p00x10p00 m=1
XR1 NB NC VSS ppolyf_u r_width=2u r_length=119.47u m=1
XR2F PTAT T5 VSS ppolyf_u r_width=2u r_length=2652.6u m=1
XR2T5 T5 T4 VSS ppolyf_u r_width=2u r_length=229.71u m=1
XR2T4 T4 T3 VSS ppolyf_u r_width=2u r_length=114.69u m=1
XR2T3 T3 T2 VSS ppolyf_u r_width=2u r_length=57.18u m=1
XR2T2 T2 T1 VSS ppolyf_u r_width=2u r_length=28.42u m=1
XR2T1 T1 T0 VSS ppolyf_u r_width=2u r_length=14.03u m=1
XR2T0 T0 VSS VSS ppolyf_u r_width=2u r_length=6.85u m=1
XRISO NA CTAT VSS ppolyf_u r_width=2u r_length=111.05u m=1
XSW5 T5 VDD T4 VSS nfet_03v3 L=0.5u W=32u nf=1 ad='int((nf+1)/2) * W/nf * 0.18u' as='int((nf+2)/2) * W/nf * 0.18u' pd='2*int((nf+1)/2) * (W/nf + 0.18u)'
+ ps='2*int((nf+2)/2) * (W/nf + 0.18u)' nrd='0.18u / W' nrs='0.18u / W' sa=0 sb=0 sd=0 m=1
XSW4 T4 VSS T3 VSS nfet_03v3 L=0.5u W=32u nf=1 ad='int((nf+1)/2) * W/nf * 0.18u' as='int((nf+2)/2) * W/nf * 0.18u' pd='2*int((nf+1)/2) * (W/nf + 0.18u)'
+ ps='2*int((nf+2)/2) * (W/nf + 0.18u)' nrd='0.18u / W' nrs='0.18u / W' sa=0 sb=0 sd=0 m=1
XSW3 T3 VSS T2 VSS nfet_03v3 L=0.5u W=32u nf=1 ad='int((nf+1)/2) * W/nf * 0.18u' as='int((nf+2)/2) * W/nf * 0.18u' pd='2*int((nf+1)/2) * (W/nf + 0.18u)'
+ ps='2*int((nf+2)/2) * (W/nf + 0.18u)' nrd='0.18u / W' nrs='0.18u / W' sa=0 sb=0 sd=0 m=1
XSW2 T2 VSS T1 VSS nfet_03v3 L=0.5u W=32u nf=1 ad='int((nf+1)/2) * W/nf * 0.18u' as='int((nf+2)/2) * W/nf * 0.18u' pd='2*int((nf+1)/2) * (W/nf + 0.18u)'
+ ps='2*int((nf+2)/2) * (W/nf + 0.18u)' nrd='0.18u / W' nrs='0.18u / W' sa=0 sb=0 sd=0 m=1
XSW1 T1 VSS T0 VSS nfet_03v3 L=0.5u W=32u nf=1 ad='int((nf+1)/2) * W/nf * 0.18u' as='int((nf+2)/2) * W/nf * 0.18u' pd='2*int((nf+1)/2) * (W/nf + 0.18u)'
+ ps='2*int((nf+2)/2) * (W/nf + 0.18u)' nrd='0.18u / W' nrs='0.18u / W' sa=0 sb=0 sd=0 m=1
XSW0 T0 VSS VSS VSS nfet_03v3 L=0.5u W=32u nf=1 ad='int((nf+1)/2) * W/nf * 0.18u' as='int((nf+2)/2) * W/nf * 0.18u' pd='2*int((nf+1)/2) * (W/nf + 0.18u)'
+ ps='2*int((nf+2)/2) * (W/nf + 0.18u)' nrd='0.18u / W' nrs='0.18u / W' sa=0 sb=0 sd=0 m=1
.ends
