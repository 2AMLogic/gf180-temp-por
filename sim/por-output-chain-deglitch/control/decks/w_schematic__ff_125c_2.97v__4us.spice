* por-output-chain-deglitch glitch-width sweep -- schematic @ ff / 125 C / 2.97 V, 4 us glitch -- GENERATED by run_glitch_width_sweep.py, do not edit
* pdk=gf180mcuD@c6d73a35f524070e85faff4a6a9eef49553ebc2b

.param vdd_val=2.97
.param t_glitch_lo=0.0009999
.param t_glitch_hi=0.001
.param t_glitch_end=0.0010040000000000001
.param t_glitch_up=0.0010041000000000002
.param stop_s=0.00108

.include "/home/ubuntu/.volare/gf180mcuD/libs.tech/ngspice/design.ngspice"
.lib "/home/ubuntu/.volare/gf180mcuD/libs.tech/ngspice/sm141064.ngspice" ff
.lib "/home/ubuntu/.volare/gf180mcuD/libs.tech/ngspice/sm141064.ngspice" res_ff
.lib "/home/ubuntu/.volare/gf180mcuD/libs.tech/ngspice/sm141064.ngspice" bjt_ff
.lib "/home/ubuntu/.volare/gf180mcuD/libs.tech/ngspice/sm141064.ngspice" diode_ff
.lib "/home/ubuntu/.volare/gf180mcuD/libs.tech/ngspice/sm141064.ngspice" moscap_ff
.lib "/home/ubuntu/.volare/gf180mcuD/libs.tech/ngspice/sm141064.ngspice" mimcap_ff

.temp 125.0
.options reltol=1e-5
.options abstol=1e-15
.options vntol=1e-8
.options method=gear

.include "../glitch_width_sweep.spice"
.include "dut_schematic.spice"

.tran 2e-08 {stop_s}

.meas tran timbefore find v(xdut1.tim) at=0.000999
.meas tran pgdgmin min v(xdut1.pgdg) from=0.0009999 to=0.0010440000000000002
.meas tran pgdgbmax max v(xdut1.pgdgb) from=0.0009999 to=0.0010440000000000002
.meas tran timafter min v(xdut1.tim) from=0.0009999 to=0.0010440000000000002

.end
