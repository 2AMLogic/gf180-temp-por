* extracted by klt extract --deck gf180mcu

* cell temp_por_top
* pin CTAT
* pin EN,RESETn
* pin PTAT
* pin VDD
* pin VSS
* pin vsubs
.SUBCKT temp_por_top CTAT EN|RESETn PTAT VDD VSS vsubs
* device instance $1 r0 *1 112.4,-399 nfet
M$1 \$19 \$19 VSS vsubs nfet L=4U W=2U AS=1.6P AD=1.6P PS=5.6U PD=5.6U
* device instance $2 r0 *1 119,-399 nfet
M$2 \$7 \$19 VSS vsubs nfet L=4U W=2U AS=1.6P AD=1.6P PS=5.6U PD=5.6U
* device instance $3 r0 *1 127.6,-398 nfet
M$3 \$22 \$22 VSS vsubs nfet L=8U W=4U AS=3.2P AD=3.2P PS=9.6U PD=9.6U
* device instance $4 r0 *1 138.2,-398 nfet
M$4 \$23 \$22 VSS vsubs nfet L=8U W=4U AS=3.2P AD=3.2P PS=9.6U PD=9.6U
* device instance $5 r0 *1 148.8,-396 nfet
M$5 \$6 \$23 VSS vsubs nfet L=8U W=8U AS=6.4P AD=6.4P PS=17.6U PD=17.6U
* device instance $6 r0 *1 159.4,-399.5 nfet
M$6 VDD VDD \$29 vsubs nfet L=8U W=1U AS=0.8P AD=0.8P PS=3.6U PD=3.6U
* device instance $7 r0 *1 170,-399.5 nfet
M$7 \$29 \$29 \$30 vsubs nfet L=8U W=1U AS=0.8P AD=0.8P PS=3.6U PD=3.6U
* device instance $8 r0 *1 180.6,-399.5 nfet
M$8 \$30 \$30 \$31 vsubs nfet L=8U W=1U AS=0.8P AD=0.8P PS=3.6U PD=3.6U
* device instance $9 r0 *1 191.2,-399.5 nfet
M$9 \$31 \$31 \$32 vsubs nfet L=8U W=1U AS=0.8P AD=0.8P PS=3.6U PD=3.6U
* device instance $10 r0 *1 201.8,-399.5 nfet
M$10 \$32 \$32 \$33 vsubs nfet L=8U W=1U AS=0.8P AD=0.8P PS=3.6U PD=3.6U
* device instance $11 r0 *1 210.4,-399 nfet
M$11 \$24 \$24 VSS vsubs nfet L=4U W=2U AS=1.6P AD=1.6P PS=5.6U PD=5.6U
* device instance $12 r0 *1 217,-396 nfet
M$12 \$33 \$24 VSS vsubs nfet L=4U W=8U AS=6.4P AD=6.4P PS=17.6U PD=17.6U
* device instance $13 r0 *1 223.6,-399.5 nfet
M$13 \$6 \$33 VSS vsubs nfet L=4U W=1U AS=0.8P AD=0.8P PS=3.6U PD=3.6U
* device instance $14 r0 *1 230.2,-399 nfet
M$14 \$27 \$27 VSS vsubs nfet L=4U W=2U AS=1.6P AD=1.6P PS=5.6U PD=5.6U
* device instance $15 r0 *1 236.8,-399 nfet
M$15 \$26 \$27 VSS vsubs nfet L=4U W=2U AS=1.6P AD=1.6P PS=5.6U PD=5.6U
* device instance $16 r0 *1 241.9,-399 nfet
M$16 \$26 \$33 VSS vsubs nfet L=1U W=2U AS=1.6P AD=1.6P PS=5.6U PD=5.6U
* device instance $17 r0 *1 247,-399 nfet
M$17 \$28 \$26 VSS vsubs nfet L=4U W=2U AS=1.6P AD=1.6P PS=5.6U PD=5.6U
* device instance $18 r0 *1 251.85,-398 nfet
M$18 BIAS_OK \$28 VSS vsubs nfet L=0.5U W=4U AS=3.2P AD=3.2P PS=9.6U PD=9.6U
* device instance $19 r0 *1 471.8,-399 nfet
M$19 \$35 \$10 \$38 vsubs nfet L=1U W=2U AS=1.6P AD=1.6P PS=5.6U PD=5.6U
* device instance $20 r0 *1 475.4,-399 nfet
M$20 \$36 VREF \$38 vsubs nfet L=1U W=2U AS=1.6P AD=1.6P PS=5.6U PD=5.6U
* device instance $21 r0 *1 483.5,-399.5 nfet
M$21 \$38 \$11 VSS vsubs nfet L=10U W=1U AS=0.8P AD=0.8P PS=3.6U PD=3.6U
* device instance $22 r0 *1 492.1,-399 nfet
M$22 IBIAS \$11 VSS vsubs nfet L=2U W=2U AS=1.6P AD=1.6P PS=5.6U PD=5.6U
* device instance $23 r0 *1 495.95,-399 nfet
M$23 IBIAS BIAS_OK \$11 vsubs nfet L=0.5U W=2U AS=1.6P AD=1.6P PS=5.6U PD=5.6U
* device instance $24 r0 *1 499.05,-399 nfet
M$24 \$11 BIAS_OKB VSS vsubs nfet L=0.5U W=2U AS=1.6P AD=1.6P PS=5.6U PD=5.6U
* device instance $25 r0 *1 502.4,-399.5 nfet
M$25 IBIAS BIAS_OKB VSS vsubs nfet L=1U W=1U AS=0.8P AD=0.8P PS=3.6U PD=3.6U
* device instance $26 r0 *1 505.75,-395 nfet
M$26 \$39 \$37 VSS vsubs nfet L=0.5U W=10U AS=8P AD=8P PS=21.6U PD=21.6U
* device instance $27 r0 *1 509.1,-399 nfet
M$27 \$36 BIAS_OKB VSS vsubs nfet L=1U W=2U AS=1.6P AD=1.6P PS=5.6U PD=5.6U
* device instance $28 r0 *1 512.45,-399.5 nfet
M$28 \$37 \$36 VSS vsubs nfet L=0.5U W=1U AS=0.8P AD=0.8P PS=3.6U PD=3.6U
* device instance $29 r0 *1 515.55,-399.5 nfet
M$29 POR_RAW \$37 VSS vsubs nfet L=0.5U W=1U AS=0.8P AD=0.8P PS=3.6U PD=3.6U
* device instance $30 r0 *1 523.35,-399.5 nfet
M$30 BIAS_OKB BIAS_OK VSS vsubs nfet L=0.5U W=1U AS=0.5P AD=0.8P PS=3U PD=3.6U
* device instance $31 r0 *1 822.8,-398 nfet
M$31 IBIAS IBIAS VSS vsubs nfet L=4U W=4U AS=3.2P AD=3.2P PS=9.6U PD=9.6U
* device instance $32 r0 *1 839.9,-399.75 nfet
M$32 \$12 IBIAS VSS vsubs nfet L=25U W=0.5U AS=0.4P AD=0.4P PS=2.6U PD=2.6U
* device instance $33 r0 *1 860,-399 nfet
M$33 \$13 \$13 VSS vsubs nfet L=10U W=2U AS=1.6P AD=1.6P PS=5.6U PD=5.6U
* device instance $34 r0 *1 872.6,-395 nfet
M$34 \$40 \$13 VSS vsubs nfet L=10U W=10U AS=8P AD=8P PS=21.6U PD=21.6U
* device instance $35 r0 *1 880.45,-399.5 nfet
M$35 \$41 POR_RAW \$40 vsubs nfet L=0.5U W=1U AS=0.8P AD=0.8P PS=3.6U PD=3.6U
* device instance $36 r0 *1 883.55,-399 nfet
M$36 \$42 \$41 VSS vsubs nfet L=0.5U W=2U AS=1.6P AD=1.6P PS=5.6U PD=5.6U
* device instance $37 r0 *1 887.4,-399.75 nfet
M$37 \$14 \$42 VSS vsubs nfet L=2U W=0.5U AS=0.4P AD=0.4P PS=2.6U PD=2.6U
* device instance $38 r0 *1 891.5,-399.5 nfet
M$38 \$43 \$14 VSS vsubs nfet L=1U W=1U AS=0.8P AD=0.8P PS=3.6U PD=3.6U
* device instance $39 r0 *1 899.6,-399.75 nfet
M$39 \$15 \$13 VSS vsubs nfet L=10U W=0.5U AS=0.4P AD=0.4P PS=2.6U PD=2.6U
* device instance $40 r0 *1 907.7,-399.5 nfet
M$40 \$44 \$15 VSS vsubs nfet L=1U W=1U AS=0.8P AD=0.8P PS=3.6U PD=3.6U
* device instance $41 r0 *1 911.05,-399 nfet
M$41 \$47 \$44 \$45 vsubs nfet L=0.5U W=2U AS=1.6P AD=1.6P PS=5.6U PD=5.6U
* device instance $42 r0 *1 914.15,-399 nfet
M$42 \$45 \$42 VSS vsubs nfet L=0.5U W=2U AS=1.6P AD=1.6P PS=5.6U PD=5.6U
* device instance $43 r0 *1 1028.65,-395 nfet
M$43 EN|RESETn \$47 VSS vsubs nfet L=0.5U W=10U AS=8P AD=8P PS=21.6U PD=21.6U
* device instance $44 r0 *1 49.5,-2 nfet
M$44 VSS VSS VSS vsubs nfet L=8U W=4U AS=3.2P AD=3.2P PS=9.6U PD=9.6U
* device instance $45 r0 *1 59.6,-2 nfet
M$45 N1 N1 VSS vsubs nfet L=8U W=4U AS=3.2P AD=3.2P PS=9.6U PD=9.6U
* device instance $46 r0 *1 69.7,-2 nfet
M$46 N2 N1 VSS vsubs nfet L=8U W=4U AS=3.2P AD=3.2P PS=9.6U PD=9.6U
* device instance $47 r0 *1 79.8,-2 nfet
M$47 N2 N1 VSS vsubs nfet L=8U W=4U AS=3.2P AD=3.2P PS=9.6U PD=9.6U
* device instance $48 r0 *1 89.9,-2 nfet
M$48 N1 N1 VSS vsubs nfet L=8U W=4U AS=3.2P AD=3.2P PS=9.6U PD=9.6U
* device instance $49 r0 *1 100,-2 nfet
M$49 VSS VSS VSS vsubs nfet L=8U W=4U AS=3.2P AD=3.2P PS=9.6U PD=9.6U
* device instance $50 r0 *1 177.5,-4 nfet
M$50 PG N2 VSS vsubs nfet L=8U W=8U AS=6.4P AD=6.4P PS=17.6U PD=17.6U
* device instance $51 r0 *1 190.7,-2 nfet
M$51 IBIAS NBG VSS vsubs nfet L=2U W=4U AS=3.2P AD=3.2P PS=9.6U PD=9.6U
* device instance $52 r0 *1 194.05,-1 nfet
M$52 IBIAS EN|RESETn NBG vsubs nfet L=0.5U W=2U AS=1.6P AD=1.6P PS=5.6U PD=5.6U
* device instance $53 r0 *1 196.65,-1 nfet
M$53 NBG ENB VSS vsubs nfet L=0.5U W=2U AS=1.6P AD=1.6P PS=5.6U PD=5.6U
* device instance $54 r0 *1 200,-2 nfet
M$54 PB NBG VSS vsubs nfet L=2U W=4U AS=3.2P AD=3.2P PS=9.6U PD=9.6U
* device instance $55 r0 *1 210.2,-2 nfet
M$55 PCAS NBG VSS vsubs nfet L=2U W=4U AS=3.2P AD=3.2P PS=9.6U PD=9.6U
* device instance $56 r0 *1 226.25,-0.5 nfet
M$56 ENB EN|RESETn VSS vsubs nfet L=0.5U W=1U AS=0.8P AD=0.8P PS=3.6U PD=3.6U
* device instance $57 r0 *1 239.7,-1 nfet
M$57 ND NR VSS vsubs nfet L=2U W=2U AS=1.6P AD=1.6P PS=5.6U PD=5.6U
* device instance $58 r0 *1 243.3,-2 nfet
M$58 PG ND VSS vsubs nfet L=1U W=4U AS=3.2P AD=3.2P PS=9.6U PD=9.6U
* device instance $59 r0 *1 253,-1 nfet
M$59 NR NR VSS vsubs nfet L=2U W=2U AS=1.6P AD=1.6P PS=5.6U PD=5.6U
* device instance $60 r0 *1 256.35,-1 nfet
M$60 ND ENB VSS vsubs nfet L=0.5U W=2U AS=1.6P AD=1.6P PS=5.6U PD=5.6U
* device instance $61 r0 *1 261.8,-0.5 nfet
M$61 PTAT ENB VSS vsubs nfet L=1U W=1U AS=0.8P AD=0.8P PS=3.6U PD=3.6U
* device instance $62 r0 *1 264.9,-0.5 nfet
M$62 CTAT ENB VSS vsubs nfet L=1U W=1U AS=0.8P AD=0.8P PS=3.6U PD=3.6U
* device instance $63 r0 *1 268,-1 nfet
M$63 N2 ENB VSS vsubs nfet L=1U W=2U AS=1.6P AD=1.6P PS=5.6U PD=5.6U
* device instance $64 r0 *1 271.1,-1 nfet
M$64 NT ENB VSS vsubs nfet L=1U W=2U AS=1.6P AD=1.6P PS=5.6U PD=5.6U
* device instance $65 r0 *1 273.95,-16 nfet
M$65 T5 VDD T4 vsubs nfet L=0.5U W=32U AS=25.6P AD=25.6P PS=65.6U PD=65.6U
* device instance $66 r0 *1 276.55,-16 nfet
M$66 T3 VSS T2 vsubs nfet L=0.5U W=32U AS=25.6P AD=25.6P PS=65.6U PD=65.6U
* device instance $67 r0 *1 279.15,-16 nfet
M$67 T1 VSS T0 vsubs nfet L=0.5U W=32U AS=25.6P AD=25.6P PS=65.6U PD=65.6U
* device instance $68 r0 *1 281.75,-16 nfet
M$68 T0 VSS VSS vsubs nfet L=0.5U W=32U AS=25.6P AD=25.6P PS=65.6U PD=65.6U
* device instance $69 r0 *1 284.35,-16 nfet
M$69 T2 VSS T1 vsubs nfet L=0.5U W=32U AS=25.6P AD=25.6P PS=65.6U PD=65.6U
* device instance $70 r0 *1 286.95,-16 nfet
M$70 T4 VSS T3 vsubs nfet L=0.5U W=32U AS=25.6P AD=25.6P PS=65.6U PD=65.6U
* device instance $71 r0 *1 2.8,-396 pfet
M$71 \$17 \$6 VDD \$52 pfet L=4U W=8U AS=6.4P AD=6.4P PS=17.6U PD=17.6U
* device instance $72 r0 *1 9.4,-396 pfet
M$72 \$18 \$6 VDD \$52 pfet L=4U W=8U AS=6.4P AD=6.4P PS=17.6U PD=17.6U
* device instance $73 r0 *1 16,-396 pfet
M$73 VREF \$6 VDD \$52 pfet L=4U W=8U AS=6.4P AD=6.4P PS=17.6U PD=17.6U
* device instance $74 r0 *1 22.6,-399 pfet
M$74 \$19 \$6 VDD \$52 pfet L=4U W=2U AS=1.6P AD=1.6P PS=5.6U PD=5.6U
* device instance $75 r0 *1 29.2,-399 pfet
M$75 \$7 \$7 VDD \$52 pfet L=4U W=2U AS=1.6P AD=1.6P PS=5.6U PD=5.6U
* device instance $76 r0 *1 35.8,-380 pfet
M$76 IBIAS \$7 VDD \$52 pfet L=4U W=40U AS=32P AD=32P PS=81.6U PD=81.6U
* device instance $77 r0 *1 42.4,-399 pfet
M$77 \$21 \$7 VDD \$52 pfet L=4U W=2U AS=1.6P AD=1.6P PS=5.6U PD=5.6U
* device instance $78 r0 *1 49,-392 pfet
M$78 \$22 \$17 \$21 \$52 pfet L=4U W=16U AS=12.8P AD=12.8P PS=33.6U PD=33.6U
* device instance $79 r0 *1 55.6,-392 pfet
M$79 \$23 \$8 \$21 \$52 pfet L=4U W=16U AS=12.8P AD=12.8P PS=33.6U PD=33.6U
* device instance $80 r0 *1 62.2,-399 pfet
M$80 \$6 \$7 VDD \$52 pfet L=4U W=2U AS=1.6P AD=1.6P PS=5.6U PD=5.6U
* device instance $81 r0 *1 68.8,-399.5 pfet
M$81 \$24 \$7 VDD \$52 pfet L=4U W=1U AS=0.8P AD=0.8P PS=3.6U PD=3.6U
* device instance $82 r0 *1 75.4,-399.5 pfet
M$82 \$25 \$7 VDD \$52 pfet L=4U W=1U AS=0.8P AD=0.8P PS=3.6U PD=3.6U
* device instance $83 r0 *1 82,-396 pfet
M$83 \$26 \$17 \$25 \$52 pfet L=4U W=8U AS=6.4P AD=6.4P PS=17.6U PD=17.6U
* device instance $84 r0 *1 88.6,-396 pfet
M$84 \$27 \$18 \$25 \$52 pfet L=4U W=8U AS=6.4P AD=6.4P PS=17.6U PD=17.6U
* device instance $85 r0 *1 95.2,-399.5 pfet
M$85 \$28 \$7 VDD \$52 pfet L=4U W=1U AS=0.8P AD=0.8P PS=3.6U PD=3.6U
* device instance $86 r0 *1 101.8,-399.5 pfet
M$86 BIAS_OK \$28 VDD \$52 pfet L=4U W=1U AS=0.8P AD=0.8P PS=3.6U PD=3.6U
* device instance $87 r0 *1 451.3,-398 pfet
M$87 \$35 \$35 \$34 \$50 pfet L=1U W=4U AS=3.2P AD=3.2P PS=9.6U PD=9.6U
* device instance $88 r0 *1 454.9,-398 pfet
M$88 \$36 \$35 \$34 \$50 pfet L=1U W=4U AS=3.2P AD=3.2P PS=9.6U PD=9.6U
* device instance $89 r0 *1 458.25,-398 pfet
M$89 \$34 BIAS_OKB VDD \$50 pfet L=0.5U W=4U AS=3.2P AD=3.2P PS=9.6U PD=9.6U
* device instance $90 r0 *1 461.35,-399 pfet
M$90 \$37 \$36 VDD \$50 pfet L=0.5U W=2U AS=1.6P AD=1.6P PS=5.6U PD=5.6U
* device instance $91 r0 *1 464.45,-399 pfet
M$91 POR_RAW \$37 VDD \$50 pfet L=0.5U W=2U AS=1.6P AD=1.6P PS=5.6U PD=5.6U
* device instance $92 r0 *1 926,-399 pfet
M$92 \$12 \$12 VDD \$51 pfet L=10U W=2U AS=1.6P AD=1.6P PS=5.6U PD=5.6U
* device instance $93 r0 *1 938.6,-399 pfet
M$93 \$13 \$12 VDD \$51 pfet L=10U W=2U AS=1.6P AD=1.6P PS=5.6U PD=5.6U
* device instance $94 r0 *1 951.2,-395 pfet
M$94 \$46 \$12 VDD \$51 pfet L=10U W=10U AS=8P AD=8P PS=21.6U PD=21.6U
* device instance $95 r0 *1 963.8,-399.75 pfet
M$95 \$16 \$12 VDD \$51 pfet L=10U W=0.5U AS=0.4P AD=0.4P PS=2.6U PD=2.6U
* device instance $96 r0 *1 976.4,-399.75 pfet
M$96 \$44 \$12 VDD \$51 pfet L=10U W=0.5U AS=0.4P AD=0.4P PS=2.6U PD=2.6U
* device instance $97 r0 *1 984.25,-399.5 pfet
M$97 \$41 POR_RAW \$46 \$51 pfet L=0.5U W=1U AS=0.8P AD=0.8P PS=3.6U PD=3.6U
* device instance $98 r0 *1 988.1,-399.75 pfet
M$98 \$42 \$41 VDD \$51 pfet L=2U W=0.5U AS=0.4P AD=0.4P PS=2.6U PD=2.6U
* device instance $99 r0 *1 991.95,-399 pfet
M$99 \$14 \$42 VDD \$51 pfet L=0.5U W=2U AS=1.6P AD=1.6P PS=5.6U PD=5.6U
* device instance $100 r0 *1 995.3,-399 pfet
M$100 \$43 \$14 \$16 \$51 pfet L=1U W=2U AS=1.6P AD=1.6P PS=5.6U PD=5.6U
* device instance $101 r0 *1 998.9,-399 pfet
M$101 \$15 \$43 VDD \$51 pfet L=1U W=2U AS=1.6P AD=1.6P PS=5.6U PD=5.6U
* device instance $102 r0 *1 1002.25,-398 pfet
M$102 \$47 \$44 VDD \$51 pfet L=0.5U W=4U AS=3.2P AD=3.2P PS=9.6U PD=9.6U
* device instance $103 r0 *1 1005.35,-398 pfet
M$103 \$47 \$42 VDD \$51 pfet L=0.5U W=4U AS=3.2P AD=3.2P PS=9.6U PD=9.6U
* device instance $104 r0 *1 1013.2,-399.75 pfet
M$104 \$47 EN|RESETn VDD \$51 pfet L=10U W=0.5U AS=0.4P AD=0.4P PS=2.6U PD=2.6U
* device instance $105 r0 *1 1021.3,-399.5 pfet
M$105 EN|RESETn \$47 VDD \$51 pfet L=1U W=1U AS=0.8P AD=0.8P PS=3.6U PD=3.6U
* device instance $106 r0 *1 2.8,40 pfet
M$106 NT NT NT \$76 pfet L=4U W=16U AS=12.8P AD=12.8P PS=33.6U PD=33.6U
* device instance $107 r0 *1 8.9,40 pfet
M$107 N1 NA NT \$76 pfet L=4U W=16U AS=12.8P AD=12.8P PS=33.6U PD=33.6U
* device instance $108 r0 *1 15,40 pfet
M$108 N2 NB NT \$76 pfet L=4U W=16U AS=12.8P AD=12.8P PS=33.6U PD=33.6U
* device instance $109 r0 *1 21.1,40 pfet
M$109 N2 NB NT \$76 pfet L=4U W=16U AS=12.8P AD=12.8P PS=33.6U PD=33.6U
* device instance $110 r0 *1 27.2,40 pfet
M$110 N1 NA NT \$76 pfet L=4U W=16U AS=12.8P AD=12.8P PS=33.6U PD=33.6U
* device instance $111 r0 *1 33.3,40 pfet
M$111 NT NT NT \$76 pfet L=4U W=16U AS=12.8P AD=12.8P PS=33.6U PD=33.6U
* device instance $112 r0 *1 41.4,42 pfet
M$112 NT PB VDD \$77 pfet L=4U W=20U AS=16P AD=16P PS=41.6U PD=41.6U
* device instance $113 r0 *1 108.1,34 pfet
M$113 VDD VDD VDD \$77 pfet L=4U W=4U AS=3.2P AD=3.2P PS=9.6U PD=9.6U
* device instance $114 r0 *1 114.2,34 pfet
M$114 M1D PG VDD \$77 pfet L=4U W=4U AS=3.2P AD=3.2P PS=9.6U PD=9.6U
* device instance $115 r0 *1 118.8,34 pfet
M$115 NA PCAS M1D \$77 pfet L=1U W=4U AS=3.2P AD=3.2P PS=9.6U PD=9.6U
* device instance $116 r0 *1 123.4,34 pfet
M$116 M2D PG VDD \$77 pfet L=4U W=4U AS=3.2P AD=3.2P PS=9.6U PD=9.6U
* device instance $117 r0 *1 128,34 pfet
M$117 NB PCAS M2D \$77 pfet L=1U W=4U AS=3.2P AD=3.2P PS=9.6U PD=9.6U
* device instance $118 r0 *1 132.6,34 pfet
M$118 M3D PG VDD \$77 pfet L=4U W=4U AS=3.2P AD=3.2P PS=9.6U PD=9.6U
* device instance $119 r0 *1 137.2,34 pfet
M$119 PTAT PCAS M3D \$77 pfet L=1U W=4U AS=3.2P AD=3.2P PS=9.6U PD=9.6U
* device instance $120 r0 *1 140.3,34 pfet
M$120 PTAT PCAS M3D \$77 pfet L=1U W=4U AS=3.2P AD=3.2P PS=9.6U PD=9.6U
* device instance $121 r0 *1 144.9,34 pfet
M$121 M3D PG VDD \$77 pfet L=4U W=4U AS=3.2P AD=3.2P PS=9.6U PD=9.6U
* device instance $122 r0 *1 149.5,34 pfet
M$122 NB PCAS M2D \$77 pfet L=1U W=4U AS=3.2P AD=3.2P PS=9.6U PD=9.6U
* device instance $123 r0 *1 154.1,34 pfet
M$123 M2D PG VDD \$77 pfet L=4U W=4U AS=3.2P AD=3.2P PS=9.6U PD=9.6U
* device instance $124 r0 *1 158.7,34 pfet
M$124 NA PCAS M1D \$77 pfet L=1U W=4U AS=3.2P AD=3.2P PS=9.6U PD=9.6U
* device instance $125 r0 *1 163.3,34 pfet
M$125 M1D PG VDD \$77 pfet L=4U W=4U AS=3.2P AD=3.2P PS=9.6U PD=9.6U
* device instance $126 r0 *1 169.4,34 pfet
M$126 VDD VDD VDD \$77 pfet L=4U W=4U AS=3.2P AD=3.2P PS=9.6U PD=9.6U
* device instance $127 r0 *1 185.6,37 pfet
M$127 PG PB VDD \$77 pfet L=4U W=10U AS=8P AD=8P PS=21.6U PD=21.6U
* device instance $128 r0 *1 205.1,37 pfet
M$128 PB PB VDD \$77 pfet L=4U W=10U AS=8P AD=8P PS=21.6U PD=21.6U
* device instance $129 r0 *1 217.3,32.5 pfet
M$129 PCAS PCAS VDD \$77 pfet L=8U W=1U AS=0.8P AD=0.8P PS=3.6U PD=3.6U
* device instance $130 r0 *1 223.65,33 pfet
M$130 ENB EN|RESETn VDD \$77 pfet L=0.5U W=2U AS=1.6P AD=1.6P PS=5.6U PD=5.6U
* device instance $131 r0 *1 232.6,32.5 pfet
M$131 ND PB VDD \$77 pfet L=8U W=1U AS=0.8P AD=0.8P PS=3.6U PD=3.6U
* device instance $132 r0 *1 247.9,32.5 pfet
M$132 NR PG VDD \$77 pfet L=4U W=1U AS=0.8P AD=0.8P PS=3.6U PD=3.6U
* device instance $133 r0 *1 258.95,34 pfet
M$133 PG EN|RESETn VDD \$77 pfet L=0.5U W=4U AS=3.2P AD=3.2P PS=9.6U PD=9.6U
* device instance $134 r0 *1 523.35,-396 pfet
M$134 BIAS_OKB BIAS_OK VDD \$49 pfet L=0.5U W=2U AS=1P AD=1.6P PS=5U PD=5.6U
* device instance $10 r0 *1 0,0
R$10 \$10 \$10__par 1614.0367
* device instance $10 r0 *1 0,0
C$10 \$10__par vsubs 1.3869633e-14
* device instance $11 r0 *1 0,0
R$11 \$11 \$11__par 1516.9554
* device instance $11 r0 *1 0,0
C$11 \$11__par vsubs 2.1326008e-14
* device instance $12 r0 *1 0,0
R$12 \$12 \$12__par 4808.7621
* device instance $12 r0 *1 0,0
C$12 \$12__par vsubs 5.6004839e-14
* device instance $13 r0 *1 0,0
R$13 \$13 \$13__par 4397.8512
* device instance $13 r0 *1 0,0
C$13 \$13__par vsubs 4.6854784e-14
* device instance $14 r0 *1 0,0
R$14 \$14 \$14__par 4001.1623
* device instance $14 r0 *1 0,0
C$14 \$14__par vsubs 3.8421379e-14
* device instance $15 r0 *1 0,0
R$15 \$15 \$15__par 3938.5423
* device instance $15 r0 *1 0,0
C$15 \$15__par vsubs 3.6999905e-14
* device instance $16 r0 *1 0,0
R$16 \$16 \$16__par 3872.8202
* device instance $16 r0 *1 0,0
C$16 \$16__par vsubs 3.4324536e-14
* device instance $17 r0 *1 0,0
R$17 \$17 \$17__par 4857.571
* device instance $17 r0 *1 0,0
C$17 \$17__par vsubs 5.0163708e-14
* device instance $18 r0 *1 0,0
R$18 \$18 \$18__par 4760.1747
* device instance $18 r0 *1 0,0
C$18 \$18__par vsubs 4.6223628e-14
* device instance $19 r0 *1 0,0
R$19 \$19 \$19__par 4871.7578
* device instance $19 r0 *1 0,0
C$19 \$19__par vsubs 5.5851412e-14
* device instance $21 r0 *1 0,0
R$21 \$21 \$21__par 4684.5858
* device instance $21 r0 *1 0,0
C$21 \$21__par vsubs 4.9951788e-14
* device instance $22 r0 *1 0,0
R$22 \$22 \$22__par 4967.8583
* device instance $22 r0 *1 0,0
C$22 \$22__par vsubs 5.978126e-14
* device instance $23 r0 *1 0,0
R$23 \$23 \$23__par 4814.5763
* device instance $23 r0 *1 0,0
C$23 \$23__par vsubs 5.2604188e-14
* device instance $24 r0 *1 0,0
R$24 \$24 \$24__par 4876.8874
* device instance $24 r0 *1 0,0
C$24 \$24__par vsubs 5.7923066e-14
* device instance $25 r0 *1 0,0
R$25 \$25 \$25__par 4690.5254
* device instance $25 r0 *1 0,0
C$25 \$25__par vsubs 5.2350545e-14
* device instance $26 r0 *1 0,0
R$26 \$26 \$26__par 4792.4183
* device instance $26 r0 *1 0,0
C$26 \$26__par vsubs 5.9161863e-14
* device instance $27 r0 *1 0,0
R$27 \$27 \$27__par 4883.997
* device instance $27 r0 *1 0,0
C$27 \$27__par vsubs 6.0794305e-14
* device instance $28 r0 *1 0,0
R$28 \$28 \$28__par 4848.4085
* device instance $28 r0 *1 0,0
C$28 \$28__par vsubs 5.9751918e-14
* device instance $29 r0 *1 0,0
R$29 \$29 \$29__par 4818.8511
* device instance $29 r0 *1 0,0
C$29 \$29__par vsubs 5.4330567e-14
* device instance $30 r0 *1 0,0
R$30 \$30 \$30__par 4819.3911
* device instance $30 r0 *1 0,0
C$30 \$30__par vsubs 5.4548635e-14
* device instance $31 r0 *1 0,0
R$31 \$31 \$31__par 4819.931
* device instance $31 r0 *1 0,0
C$31 \$31__par vsubs 5.4766704e-14
* device instance $32 r0 *1 0,0
R$32 \$32 \$32__par 4820.471
* device instance $32 r0 *1 0,0
C$32 \$32__par vsubs 5.4984773e-14
* device instance $33 r0 *1 0,0
R$33 \$33 \$33__par 4848.0503
* device instance $33 r0 *1 0,0
C$33 \$33__par vsubs 5.7785044e-14
* device instance $34 r0 *1 0,0
R$34 \$34 \$34__par 1263.8244
* device instance $34 r0 *1 0,0
C$34 \$34__par vsubs 1.4679011e-14
* device instance $35 r0 *1 0,0
R$35 \$35 \$35__par 1384.846
* device instance $35 r0 *1 0,0
C$35 \$35__par vsubs 1.5868526e-14
* device instance $36 r0 *1 0,0
R$36 \$36 \$36__par 1382.1249
* device instance $36 r0 *1 0,0
C$36 \$36__par vsubs 1.7766709e-14
* device instance $37 r0 *1 0,0
R$37 \$37 \$37__par 1437.8825
* device instance $37 r0 *1 0,0
C$37 \$37__par vsubs 1.7866109e-14
* device instance $38 r0 *1 0,0
R$38 \$38 \$38__par 1261.1261
* device instance $38 r0 *1 0,0
C$38 \$38__par vsubs 1.3588667e-14
* device instance $39 r0 *1 0,0
R$39 \$39 \$39__par 1556.3463
* device instance $39 r0 *1 0,0
C$39 \$39__par vsubs 1.4392349e-14
* device instance $40 r0 *1 0,0
R$40 \$40 \$40__par 3871.3807
* device instance $40 r0 *1 0,0
C$40 \$40__par vsubs 3.3743019e-14
* device instance $41 r0 *1 0,0
R$41 \$41 \$41__par 4004.4196
* device instance $41 r0 *1 0,0
C$41 \$41__par vsubs 3.8062762e-14
* device instance $42 r0 *1 0,0
R$42 \$42 \$42__par 4123.7127
* device instance $42 r0 *1 0,0
C$42 \$42__par vsubs 4.1822839e-14
* device instance $43 r0 *1 0,0
R$43 \$43 \$43__par 3937.7776
* device instance $43 r0 *1 0,0
C$43 \$43__par vsubs 3.6690975e-14
* device instance $44 r0 *1 0,0
R$44 \$44 \$44__par 3994.4831
* device instance $44 r0 *1 0,0
C$44 \$44__par vsubs 3.8956888e-14
* device instance $45 r0 *1 0,0
R$45 \$45 \$45__par 3874.2598
* device instance $45 r0 *1 0,0
C$45 \$45__par vsubs 3.4906053e-14
* device instance $46 r0 *1 0,0
R$46 \$46 \$46__par 3871.0209
* device instance $46 r0 *1 0,0
C$46 \$46__par vsubs 3.359764e-14
* device instance $47 r0 *1 0,0
R$47 \$47 \$47__par 4010.467
* device instance $47 r0 *1 0,0
C$47 \$47__par vsubs 4.3731461e-14
* device instance $6 r0 *1 0,0
R$6 \$6 \$6__par 5084.0134
* device instance $6 r0 *1 0,0
C$6 \$6__par vsubs 6.8147207e-14
* device instance $7 r0 *1 0,0
R$7 \$7 \$7__par 5396.0003
* device instance $7 r0 *1 0,0
C$7 \$7__par vsubs 7.9168117e-14
* device instance $8 r0 *1 0,0
R$8 \$8 \$8__par 4747.4272
* device instance $8 r0 *1 0,0
C$8 \$8__par vsubs 4.1117441e-14
* device instance BIAS_OK r0 *1 0,0
RBIAS_OK BIAS_OK BIAS_OK__par 6145.4389
* device instance BIAS_OK r0 *1 0,0
CBIAS_OK BIAS_OK__par vsubs 6.2768673e-14
* device instance BIAS_OKB r0 *1 0,0
RBIAS_OKB BIAS_OKB BIAS_OKB__par 1631.1837
* device instance BIAS_OKB r0 *1 0,0
CBIAS_OKB BIAS_OKB__par vsubs 2.1659338e-14
* device instance CTAT r0 *1 0,0
RCTAT CTAT CTAT__par 474.7403
* device instance CTAT r0 *1 0,0
CCTAT CTAT__par vsubs 2.7195352e-14
* device instance EN,RESETn r0 *1 0,0
REN,RESETn EN|RESETn EN|RESETn__par 5439.8618
* device instance EN,RESETn r0 *1 0,0
CEN,RESETn EN|RESETn__par vsubs 7.4268733e-14
* device instance ENB r0 *1 0,0
RENB ENB ENB__par 1686.1221
* device instance ENB r0 *1 0,0
CENB ENB__par vsubs 3.6146108e-14
* device instance IBIAS r0 *1 0,0
RIBIAS IBIAS IBIAS__par 10576.1726
* device instance IBIAS r0 *1 0,0
CIBIAS IBIAS__par vsubs 1.22084094e-13
* device instance M1D r0 *1 0,0
RM1D M1D M1D__par 1180.5884
* device instance M1D r0 *1 0,0
CM1D M1D__par vsubs 2.5430782e-14
* device instance M2D r0 *1 0,0
RM2D M2D M2D__par 1105.0547
* device instance M2D r0 *1 0,0
CM2D M2D__par vsubs 2.403986e-14
* device instance M3D r0 *1 0,0
RM3D M3D M3D__par 1029.5295
* device instance M3D r0 *1 0,0
CM3D M3D__par vsubs 2.2648937e-14
* device instance N1 r0 *1 0,0
RN1 N1 N1__par 3844.0985
* device instance N1 r0 *1 0,0
CN1 N1__par vsubs 3.8589379e-14
* device instance N2 r0 *1 0,0
RN2 N2 N2__par 2240.7855
* device instance N2 r0 *1 0,0
CN2 N2__par vsubs 4.4032876e-14
* device instance NA r0 *1 0,0
RNA NA NA__par 1928.7659
* device instance NA r0 *1 0,0
CNA NA__par vsubs 2.9097844e-14
* device instance NB r0 *1 0,0
RNB NB NB__par 1853.5061
* device instance NB r0 *1 0,0
CNB NB__par vsubs 2.7706922e-14
* device instance NBG r0 *1 0,0
RNBG NBG NBG__par 1144.9314
* device instance NBG r0 *1 0,0
CNBG NBG__par vsubs 2.6946068e-14
* device instance ND r0 *1 0,0
RND ND ND__par 1476.2059
* device instance ND r0 *1 0,0
CND ND__par vsubs 3.4480799e-14
* device instance NR r0 *1 0,0
RNR NR NR__par 1658.5064
* device instance NR r0 *1 0,0
CNR NR__par vsubs 3.5110516e-14
* device instance NT r0 *1 0,0
RNT NT NT__par 5050.5517
* device instance NT r0 *1 0,0
CNT NT__par vsubs 7.5724293e-14
* device instance PB r0 *1 0,0
RPB PB PB__par 3354.4466
* device instance PB r0 *1 0,0
CPB PB__par vsubs 4.5703065e-14
* device instance PCAS r0 *1 0,0
RPCAS PCAS PCAS__par 4257.7848
* device instance PCAS r0 *1 0,0
CPCAS PCAS__par vsubs 5.1430208e-14
* device instance PG r0 *1 0,0
RPG PG PG__par 4774.5776
* device instance PG r0 *1 0,0
CPG PG__par vsubs 5.9115143e-14
* device instance POR_RAW r0 *1 0,0
RPOR_RAW POR_RAW POR_RAW__par 5256.9367
* device instance POR_RAW r0 *1 0,0
CPOR_RAW POR_RAW__par vsubs 4.7221812e-14
* device instance PTAT r0 *1 0,0
RPTAT PTAT PTAT__par 847.1419
* device instance PTAT r0 *1 0,0
CPTAT PTAT__par vsubs 3.0557482e-14
* device instance T0 r0 *1 0,0
RT0 T0 T0__par 1166.127
* device instance T0 r0 *1 0,0
CT0 T0__par vsubs 3.9524362e-14
* device instance T1 r0 *1 0,0
RT1 T1 T1__par 1129.9138
* device instance T1 r0 *1 0,0
CT1 T1__par vsubs 3.9324288e-14
* device instance T2 r0 *1 0,0
RT2 T2 T2__par 1093.8697
* device instance T2 r0 *1 0,0
CT2 T2__par vsubs 3.9177292e-14
* device instance T3 r0 *1 0,0
RT3 T3 T3__par 1057.6573
* device instance T3 r0 *1 0,0
CT3 T3__par vsubs 3.8977218e-14
* device instance T4 r0 *1 0,0
RT4 T4 T4__par 1021.6142
* device instance T4 r0 *1 0,0
CT4 T4__par vsubs 3.8830221e-14
* device instance T5 r0 *1 0,0
RT5 T5 T5__par 522.434
* device instance T5 r0 *1 0,0
CT5 T5__par vsubs 3.1004675e-14
* device instance VDD r0 *1 0,0
RVDD VDD VDD__par 11430.0429
* device instance VDD r0 *1 0,0
CVDD VDD__par vsubs 3.37770075e-13
* device instance VREF r0 *1 0,0
RVREF VREF VREF__par 5992.9627
* device instance VREF r0 *1 0,0
CVREF VREF__par vsubs 5.2987601e-14
* device instance VSS r0 *1 0,0
RVSS VSS VSS__par 3249.111
* device instance VSS r0 *1 0,0
CVSS VSS__par vsubs 1.475056302e-12
.ENDS temp_por_top
