* extracted by klt extract --deck gf180mcu

* cell temp_por_top
* pin CTAT
* pin EN,RESETn
* pin PTAT
* pin VDD
* pin VSS
* pin vsubs
.SUBCKT temp_por_top CTAT EN|RESETn PTAT VDD VSS vsubs
* device instance $1 r0 *1 112.4,-399 nfet
M$1 \$19 \$19 VSS vsubs nfet L=4U W=2U AS=1.6P AD=1.6P PS=5.6U PD=5.6U
* device instance $2 r0 *1 119,-399 nfet
M$2 \$7 \$19 VSS vsubs nfet L=4U W=2U AS=1.6P AD=1.6P PS=5.6U PD=5.6U
* device instance $3 r0 *1 127.6,-398 nfet
M$3 \$22 \$22 VSS vsubs nfet L=8U W=4U AS=3.2P AD=3.2P PS=9.6U PD=9.6U
* device instance $4 r0 *1 138.2,-398 nfet
M$4 \$23 \$22 VSS vsubs nfet L=8U W=4U AS=3.2P AD=3.2P PS=9.6U PD=9.6U
* device instance $5 r0 *1 148.8,-396 nfet
M$5 \$6 \$23 VSS vsubs nfet L=8U W=8U AS=6.4P AD=6.4P PS=17.6U PD=17.6U
* device instance $6 r0 *1 159.4,-399.5 nfet
M$6 VDD VDD \$29 vsubs nfet L=8U W=1U AS=0.8P AD=0.8P PS=3.6U PD=3.6U
* device instance $7 r0 *1 170,-399.5 nfet
M$7 \$29 \$29 \$30 vsubs nfet L=8U W=1U AS=0.8P AD=0.8P PS=3.6U PD=3.6U
* device instance $8 r0 *1 180.6,-399.5 nfet
M$8 \$30 \$30 \$31 vsubs nfet L=8U W=1U AS=0.8P AD=0.8P PS=3.6U PD=3.6U
* device instance $9 r0 *1 191.2,-399.5 nfet
M$9 \$31 \$31 \$32 vsubs nfet L=8U W=1U AS=0.8P AD=0.8P PS=3.6U PD=3.6U
* device instance $10 r0 *1 201.8,-399.5 nfet
M$10 \$32 \$32 \$33 vsubs nfet L=8U W=1U AS=0.8P AD=0.8P PS=3.6U PD=3.6U
* device instance $11 r0 *1 210.4,-399 nfet
M$11 \$24 \$24 VSS vsubs nfet L=4U W=2U AS=1.6P AD=1.6P PS=5.6U PD=5.6U
* device instance $12 r0 *1 217,-396 nfet
M$12 \$33 \$24 VSS vsubs nfet L=4U W=8U AS=6.4P AD=6.4P PS=17.6U PD=17.6U
* device instance $13 r0 *1 223.6,-399.5 nfet
M$13 \$6 \$33 VSS vsubs nfet L=4U W=1U AS=0.8P AD=0.8P PS=3.6U PD=3.6U
* device instance $14 r0 *1 230.2,-399 nfet
M$14 \$27 \$27 VSS vsubs nfet L=4U W=2U AS=1.6P AD=1.6P PS=5.6U PD=5.6U
* device instance $15 r0 *1 236.8,-399 nfet
M$15 \$26 \$27 VSS vsubs nfet L=4U W=2U AS=1.6P AD=1.6P PS=5.6U PD=5.6U
* device instance $16 r0 *1 241.9,-399 nfet
M$16 \$26 \$33 VSS vsubs nfet L=1U W=2U AS=1.6P AD=1.6P PS=5.6U PD=5.6U
* device instance $17 r0 *1 247,-399 nfet
M$17 \$28 \$26 VSS vsubs nfet L=4U W=2U AS=1.6P AD=1.6P PS=5.6U PD=5.6U
* device instance $18 r0 *1 251.85,-398 nfet
M$18 BIAS_OK \$28 VSS vsubs nfet L=0.5U W=4U AS=3.2P AD=3.2P PS=9.6U PD=9.6U
* device instance $19 r0 *1 471.8,-399 nfet
M$19 \$35 \$10 \$38 vsubs nfet L=1U W=2U AS=1.6P AD=1.6P PS=5.6U PD=5.6U
* device instance $20 r0 *1 475.4,-399 nfet
M$20 \$36 VREF \$38 vsubs nfet L=1U W=2U AS=1.6P AD=1.6P PS=5.6U PD=5.6U
* device instance $21 r0 *1 483.5,-399.5 nfet
M$21 \$38 \$11 VSS vsubs nfet L=10U W=1U AS=0.8P AD=0.8P PS=3.6U PD=3.6U
* device instance $22 r0 *1 492.1,-399 nfet
M$22 IBIAS \$11 VSS vsubs nfet L=2U W=2U AS=1.6P AD=1.6P PS=5.6U PD=5.6U
* device instance $23 r0 *1 495.95,-399 nfet
M$23 IBIAS BIAS_OK \$11 vsubs nfet L=0.5U W=2U AS=1.6P AD=1.6P PS=5.6U PD=5.6U
* device instance $24 r0 *1 499.05,-399 nfet
M$24 \$11 BIAS_OKB VSS vsubs nfet L=0.5U W=2U AS=1.6P AD=1.6P PS=5.6U PD=5.6U
* device instance $25 r0 *1 502.4,-399.5 nfet
M$25 IBIAS BIAS_OKB VSS vsubs nfet L=1U W=1U AS=0.8P AD=0.8P PS=3.6U PD=3.6U
* device instance $26 r0 *1 505.75,-395 nfet
M$26 \$39 \$37 VSS vsubs nfet L=0.5U W=10U AS=8P AD=8P PS=21.6U PD=21.6U
* device instance $27 r0 *1 509.1,-399 nfet
M$27 \$36 BIAS_OKB VSS vsubs nfet L=1U W=2U AS=1.6P AD=1.6P PS=5.6U PD=5.6U
* device instance $28 r0 *1 512.45,-399.5 nfet
M$28 \$37 \$36 VSS vsubs nfet L=0.5U W=1U AS=0.8P AD=0.8P PS=3.6U PD=3.6U
* device instance $29 r0 *1 515.55,-399.5 nfet
M$29 POR_RAW \$37 VSS vsubs nfet L=0.5U W=1U AS=0.8P AD=0.8P PS=3.6U PD=3.6U
* device instance $30 r0 *1 523.35,-399.5 nfet
M$30 BIAS_OKB BIAS_OK VSS vsubs nfet L=0.5U W=1U AS=0.5P AD=0.8P PS=3U PD=3.6U
* device instance $31 r0 *1 822.8,-398 nfet
M$31 IBIAS IBIAS VSS vsubs nfet L=4U W=4U AS=3.2P AD=3.2P PS=9.6U PD=9.6U
* device instance $32 r0 *1 839.9,-399.75 nfet
M$32 \$12 IBIAS VSS vsubs nfet L=25U W=0.5U AS=0.4P AD=0.4P PS=2.6U PD=2.6U
* device instance $33 r0 *1 860,-399 nfet
M$33 \$13 \$13 VSS vsubs nfet L=10U W=2U AS=1.6P AD=1.6P PS=5.6U PD=5.6U
* device instance $34 r0 *1 872.6,-395 nfet
M$34 \$40 \$13 VSS vsubs nfet L=10U W=10U AS=8P AD=8P PS=21.6U PD=21.6U
* device instance $35 r0 *1 880.45,-399.5 nfet
M$35 \$41 POR_RAW \$40 vsubs nfet L=0.5U W=1U AS=0.8P AD=0.8P PS=3.6U PD=3.6U
* device instance $36 r0 *1 883.55,-399 nfet
M$36 \$42 \$41 VSS vsubs nfet L=0.5U W=2U AS=1.6P AD=1.6P PS=5.6U PD=5.6U
* device instance $37 r0 *1 887.4,-399.75 nfet
M$37 \$14 \$42 VSS vsubs nfet L=2U W=0.5U AS=0.4P AD=0.4P PS=2.6U PD=2.6U
* device instance $38 r0 *1 891.5,-399.5 nfet
M$38 \$43 \$14 VSS vsubs nfet L=1U W=1U AS=0.8P AD=0.8P PS=3.6U PD=3.6U
* device instance $39 r0 *1 899.6,-399.75 nfet
M$39 \$15 \$13 VSS vsubs nfet L=10U W=0.5U AS=0.4P AD=0.4P PS=2.6U PD=2.6U
* device instance $40 r0 *1 907.7,-399.5 nfet
M$40 \$44 \$15 VSS vsubs nfet L=1U W=1U AS=0.8P AD=0.8P PS=3.6U PD=3.6U
* device instance $41 r0 *1 911.05,-399 nfet
M$41 \$47 \$44 \$45 vsubs nfet L=0.5U W=2U AS=1.6P AD=1.6P PS=5.6U PD=5.6U
* device instance $42 r0 *1 914.15,-399 nfet
M$42 \$45 \$42 VSS vsubs nfet L=0.5U W=2U AS=1.6P AD=1.6P PS=5.6U PD=5.6U
* device instance $43 r0 *1 1028.65,-395 nfet
M$43 EN|RESETn \$47 VSS vsubs nfet L=0.5U W=10U AS=8P AD=8P PS=21.6U PD=21.6U
* device instance $44 r0 *1 49.5,-2 nfet
M$44 VSS VSS VSS vsubs nfet L=8U W=4U AS=3.2P AD=3.2P PS=9.6U PD=9.6U
* device instance $45 r0 *1 59.6,-2 nfet
M$45 N1 N1 VSS vsubs nfet L=8U W=4U AS=3.2P AD=3.2P PS=9.6U PD=9.6U
* device instance $46 r0 *1 69.7,-2 nfet
M$46 N2 N1 VSS vsubs nfet L=8U W=4U AS=3.2P AD=3.2P PS=9.6U PD=9.6U
* device instance $47 r0 *1 79.8,-2 nfet
M$47 N2 N1 VSS vsubs nfet L=8U W=4U AS=3.2P AD=3.2P PS=9.6U PD=9.6U
* device instance $48 r0 *1 89.9,-2 nfet
M$48 N1 N1 VSS vsubs nfet L=8U W=4U AS=3.2P AD=3.2P PS=9.6U PD=9.6U
* device instance $49 r0 *1 100,-2 nfet
M$49 VSS VSS VSS vsubs nfet L=8U W=4U AS=3.2P AD=3.2P PS=9.6U PD=9.6U
* device instance $50 r0 *1 177.5,-4 nfet
M$50 PG N2 VSS vsubs nfet L=8U W=8U AS=6.4P AD=6.4P PS=17.6U PD=17.6U
* device instance $51 r0 *1 190.7,-2 nfet
M$51 IBIAS NBG VSS vsubs nfet L=2U W=4U AS=3.2P AD=3.2P PS=9.6U PD=9.6U
* device instance $52 r0 *1 194.05,-1 nfet
M$52 IBIAS EN|RESETn NBG vsubs nfet L=0.5U W=2U AS=1.6P AD=1.6P PS=5.6U PD=5.6U
* device instance $53 r0 *1 196.65,-1 nfet
M$53 NBG ENB VSS vsubs nfet L=0.5U W=2U AS=1.6P AD=1.6P PS=5.6U PD=5.6U
* device instance $54 r0 *1 200,-2 nfet
M$54 PB NBG VSS vsubs nfet L=2U W=4U AS=3.2P AD=3.2P PS=9.6U PD=9.6U
* device instance $55 r0 *1 210.2,-2 nfet
M$55 PCAS NBG VSS vsubs nfet L=2U W=4U AS=3.2P AD=3.2P PS=9.6U PD=9.6U
* device instance $56 r0 *1 226.25,-0.5 nfet
M$56 ENB EN|RESETn VSS vsubs nfet L=0.5U W=1U AS=0.8P AD=0.8P PS=3.6U PD=3.6U
* device instance $57 r0 *1 239.7,-1 nfet
M$57 ND NR VSS vsubs nfet L=2U W=2U AS=1.6P AD=1.6P PS=5.6U PD=5.6U
* device instance $58 r0 *1 243.3,-2 nfet
M$58 PG ND VSS vsubs nfet L=1U W=4U AS=3.2P AD=3.2P PS=9.6U PD=9.6U
* device instance $59 r0 *1 253,-1 nfet
M$59 NR NR VSS vsubs nfet L=2U W=2U AS=1.6P AD=1.6P PS=5.6U PD=5.6U
* device instance $60 r0 *1 256.35,-1 nfet
M$60 ND ENB VSS vsubs nfet L=0.5U W=2U AS=1.6P AD=1.6P PS=5.6U PD=5.6U
* device instance $61 r0 *1 261.8,-0.5 nfet
M$61 PTAT ENB VSS vsubs nfet L=1U W=1U AS=0.8P AD=0.8P PS=3.6U PD=3.6U
* device instance $62 r0 *1 264.9,-0.5 nfet
M$62 CTAT ENB VSS vsubs nfet L=1U W=1U AS=0.8P AD=0.8P PS=3.6U PD=3.6U
* device instance $63 r0 *1 268,-1 nfet
M$63 N2 ENB VSS vsubs nfet L=1U W=2U AS=1.6P AD=1.6P PS=5.6U PD=5.6U
* device instance $64 r0 *1 271.1,-1 nfet
M$64 NT ENB VSS vsubs nfet L=1U W=2U AS=1.6P AD=1.6P PS=5.6U PD=5.6U
* device instance $65 r0 *1 273.95,-16 nfet
M$65 T5 VDD T4 vsubs nfet L=0.5U W=32U AS=25.6P AD=25.6P PS=65.6U PD=65.6U
* device instance $66 r0 *1 276.55,-16 nfet
M$66 T3 VSS T2 vsubs nfet L=0.5U W=32U AS=25.6P AD=25.6P PS=65.6U PD=65.6U
* device instance $67 r0 *1 279.15,-16 nfet
M$67 T1 VSS T0 vsubs nfet L=0.5U W=32U AS=25.6P AD=25.6P PS=65.6U PD=65.6U
* device instance $68 r0 *1 281.75,-16 nfet
M$68 T0 VSS VSS vsubs nfet L=0.5U W=32U AS=25.6P AD=25.6P PS=65.6U PD=65.6U
* device instance $69 r0 *1 284.35,-16 nfet
M$69 T2 VSS T1 vsubs nfet L=0.5U W=32U AS=25.6P AD=25.6P PS=65.6U PD=65.6U
* device instance $70 r0 *1 286.95,-16 nfet
M$70 T4 VSS T3 vsubs nfet L=0.5U W=32U AS=25.6P AD=25.6P PS=65.6U PD=65.6U
* device instance $71 r0 *1 2.8,-396 pfet
M$71 \$17 \$6 VDD \$55 pfet L=4U W=8U AS=6.4P AD=6.4P PS=17.6U PD=17.6U
* device instance $72 r0 *1 9.4,-396 pfet
M$72 \$18 \$6 VDD \$55 pfet L=4U W=8U AS=6.4P AD=6.4P PS=17.6U PD=17.6U
* device instance $73 r0 *1 16,-396 pfet
M$73 VREF \$6 VDD \$55 pfet L=4U W=8U AS=6.4P AD=6.4P PS=17.6U PD=17.6U
* device instance $74 r0 *1 22.6,-399 pfet
M$74 \$19 \$6 VDD \$55 pfet L=4U W=2U AS=1.6P AD=1.6P PS=5.6U PD=5.6U
* device instance $75 r0 *1 29.2,-399 pfet
M$75 \$7 \$7 VDD \$55 pfet L=4U W=2U AS=1.6P AD=1.6P PS=5.6U PD=5.6U
* device instance $76 r0 *1 35.8,-380 pfet
M$76 IBIAS \$7 VDD \$55 pfet L=4U W=40U AS=32P AD=32P PS=81.6U PD=81.6U
* device instance $77 r0 *1 42.4,-399 pfet
M$77 \$21 \$7 VDD \$55 pfet L=4U W=2U AS=1.6P AD=1.6P PS=5.6U PD=5.6U
* device instance $78 r0 *1 49,-392 pfet
M$78 \$22 \$17 \$21 \$55 pfet L=4U W=16U AS=12.8P AD=12.8P PS=33.6U PD=33.6U
* device instance $79 r0 *1 55.6,-392 pfet
M$79 \$23 \$8 \$21 \$55 pfet L=4U W=16U AS=12.8P AD=12.8P PS=33.6U PD=33.6U
* device instance $80 r0 *1 62.2,-399 pfet
M$80 \$6 \$7 VDD \$55 pfet L=4U W=2U AS=1.6P AD=1.6P PS=5.6U PD=5.6U
* device instance $81 r0 *1 68.8,-399.5 pfet
M$81 \$24 \$7 VDD \$55 pfet L=4U W=1U AS=0.8P AD=0.8P PS=3.6U PD=3.6U
* device instance $82 r0 *1 75.4,-399.5 pfet
M$82 \$25 \$7 VDD \$55 pfet L=4U W=1U AS=0.8P AD=0.8P PS=3.6U PD=3.6U
* device instance $83 r0 *1 82,-396 pfet
M$83 \$26 \$17 \$25 \$55 pfet L=4U W=8U AS=6.4P AD=6.4P PS=17.6U PD=17.6U
* device instance $84 r0 *1 88.6,-396 pfet
M$84 \$27 \$18 \$25 \$55 pfet L=4U W=8U AS=6.4P AD=6.4P PS=17.6U PD=17.6U
* device instance $85 r0 *1 95.2,-399.5 pfet
M$85 \$28 \$7 VDD \$55 pfet L=4U W=1U AS=0.8P AD=0.8P PS=3.6U PD=3.6U
* device instance $86 r0 *1 101.8,-399.5 pfet
M$86 BIAS_OK \$28 VDD \$55 pfet L=4U W=1U AS=0.8P AD=0.8P PS=3.6U PD=3.6U
* device instance $87 r0 *1 451.3,-398 pfet
M$87 \$35 \$35 \$34 \$50 pfet L=1U W=4U AS=3.2P AD=3.2P PS=9.6U PD=9.6U
* device instance $88 r0 *1 454.9,-398 pfet
M$88 \$36 \$35 \$34 \$50 pfet L=1U W=4U AS=3.2P AD=3.2P PS=9.6U PD=9.6U
* device instance $89 r0 *1 458.25,-398 pfet
M$89 \$34 BIAS_OKB VDD \$50 pfet L=0.5U W=4U AS=3.2P AD=3.2P PS=9.6U PD=9.6U
* device instance $90 r0 *1 461.35,-399 pfet
M$90 \$37 \$36 VDD \$50 pfet L=0.5U W=2U AS=1.6P AD=1.6P PS=5.6U PD=5.6U
* device instance $91 r0 *1 464.45,-399 pfet
M$91 POR_RAW \$37 VDD \$50 pfet L=0.5U W=2U AS=1.6P AD=1.6P PS=5.6U PD=5.6U
* device instance $92 r0 *1 926,-399 pfet
M$92 \$12 \$12 VDD \$51 pfet L=10U W=2U AS=1.6P AD=1.6P PS=5.6U PD=5.6U
* device instance $93 r0 *1 938.6,-399 pfet
M$93 \$13 \$12 VDD \$51 pfet L=10U W=2U AS=1.6P AD=1.6P PS=5.6U PD=5.6U
* device instance $94 r0 *1 951.2,-395 pfet
M$94 \$46 \$12 VDD \$51 pfet L=10U W=10U AS=8P AD=8P PS=21.6U PD=21.6U
* device instance $95 r0 *1 963.8,-399.75 pfet
M$95 \$16 \$12 VDD \$51 pfet L=10U W=0.5U AS=0.4P AD=0.4P PS=2.6U PD=2.6U
* device instance $96 r0 *1 976.4,-399.75 pfet
M$96 \$44 \$12 VDD \$51 pfet L=10U W=0.5U AS=0.4P AD=0.4P PS=2.6U PD=2.6U
* device instance $97 r0 *1 984.25,-399.5 pfet
M$97 \$41 POR_RAW \$46 \$51 pfet L=0.5U W=1U AS=0.8P AD=0.8P PS=3.6U PD=3.6U
* device instance $98 r0 *1 988.1,-399.75 pfet
M$98 \$42 \$41 VDD \$51 pfet L=2U W=0.5U AS=0.4P AD=0.4P PS=2.6U PD=2.6U
* device instance $99 r0 *1 991.95,-399 pfet
M$99 \$14 \$42 VDD \$51 pfet L=0.5U W=2U AS=1.6P AD=1.6P PS=5.6U PD=5.6U
* device instance $100 r0 *1 995.3,-399 pfet
M$100 \$43 \$14 \$16 \$51 pfet L=1U W=2U AS=1.6P AD=1.6P PS=5.6U PD=5.6U
* device instance $101 r0 *1 998.9,-399 pfet
M$101 \$15 \$43 VDD \$51 pfet L=1U W=2U AS=1.6P AD=1.6P PS=5.6U PD=5.6U
* device instance $102 r0 *1 1002.25,-398 pfet
M$102 \$47 \$44 VDD \$51 pfet L=0.5U W=4U AS=3.2P AD=3.2P PS=9.6U PD=9.6U
* device instance $103 r0 *1 1005.35,-398 pfet
M$103 \$47 \$42 VDD \$51 pfet L=0.5U W=4U AS=3.2P AD=3.2P PS=9.6U PD=9.6U
* device instance $104 r0 *1 1013.2,-399.75 pfet
M$104 \$47 EN|RESETn VDD \$51 pfet L=10U W=0.5U AS=0.4P AD=0.4P PS=2.6U PD=2.6U
* device instance $105 r0 *1 1021.3,-399.5 pfet
M$105 EN|RESETn \$47 VDD \$51 pfet L=1U W=1U AS=0.8P AD=0.8P PS=3.6U PD=3.6U
* device instance $106 r0 *1 2.8,42 pfet
M$106 NT NT NT \$91 pfet L=4U W=16U AS=12.8P AD=12.8P PS=33.6U PD=33.6U
* device instance $107 r0 *1 8.9,42 pfet
M$107 N1 NA NT \$91 pfet L=4U W=16U AS=12.8P AD=12.8P PS=33.6U PD=33.6U
* device instance $108 r0 *1 15,42 pfet
M$108 N2 NB NT \$91 pfet L=4U W=16U AS=12.8P AD=12.8P PS=33.6U PD=33.6U
* device instance $109 r0 *1 21.1,42 pfet
M$109 N2 NB NT \$91 pfet L=4U W=16U AS=12.8P AD=12.8P PS=33.6U PD=33.6U
* device instance $110 r0 *1 27.2,42 pfet
M$110 N1 NA NT \$91 pfet L=4U W=16U AS=12.8P AD=12.8P PS=33.6U PD=33.6U
* device instance $111 r0 *1 33.3,42 pfet
M$111 NT NT NT \$91 pfet L=4U W=16U AS=12.8P AD=12.8P PS=33.6U PD=33.6U
* device instance $112 r0 *1 41.4,44 pfet
M$112 NT PB VDD \$92 pfet L=4U W=20U AS=16P AD=16P PS=41.6U PD=41.6U
* device instance $113 r0 *1 108.1,36 pfet
M$113 VDD VDD VDD \$92 pfet L=4U W=4U AS=3.2P AD=3.2P PS=9.6U PD=9.6U
* device instance $114 r0 *1 114.2,36 pfet
M$114 M1D PG VDD \$92 pfet L=4U W=4U AS=3.2P AD=3.2P PS=9.6U PD=9.6U
* device instance $115 r0 *1 118.8,36 pfet
M$115 NA PCAS M1D \$92 pfet L=1U W=4U AS=3.2P AD=3.2P PS=9.6U PD=9.6U
* device instance $116 r0 *1 123.4,36 pfet
M$116 M2D PG VDD \$92 pfet L=4U W=4U AS=3.2P AD=3.2P PS=9.6U PD=9.6U
* device instance $117 r0 *1 128,36 pfet
M$117 NB PCAS M2D \$92 pfet L=1U W=4U AS=3.2P AD=3.2P PS=9.6U PD=9.6U
* device instance $118 r0 *1 132.6,36 pfet
M$118 M3D PG VDD \$92 pfet L=4U W=4U AS=3.2P AD=3.2P PS=9.6U PD=9.6U
* device instance $119 r0 *1 137.2,36 pfet
M$119 PTAT PCAS M3D \$92 pfet L=1U W=4U AS=3.2P AD=3.2P PS=9.6U PD=9.6U
* device instance $120 r0 *1 140.3,36 pfet
M$120 PTAT PCAS M3D \$92 pfet L=1U W=4U AS=3.2P AD=3.2P PS=9.6U PD=9.6U
* device instance $121 r0 *1 144.9,36 pfet
M$121 M3D PG VDD \$92 pfet L=4U W=4U AS=3.2P AD=3.2P PS=9.6U PD=9.6U
* device instance $122 r0 *1 149.5,36 pfet
M$122 NB PCAS M2D \$92 pfet L=1U W=4U AS=3.2P AD=3.2P PS=9.6U PD=9.6U
* device instance $123 r0 *1 154.1,36 pfet
M$123 M2D PG VDD \$92 pfet L=4U W=4U AS=3.2P AD=3.2P PS=9.6U PD=9.6U
* device instance $124 r0 *1 158.7,36 pfet
M$124 NA PCAS M1D \$92 pfet L=1U W=4U AS=3.2P AD=3.2P PS=9.6U PD=9.6U
* device instance $125 r0 *1 163.3,36 pfet
M$125 M1D PG VDD \$92 pfet L=4U W=4U AS=3.2P AD=3.2P PS=9.6U PD=9.6U
* device instance $126 r0 *1 169.4,36 pfet
M$126 VDD VDD VDD \$92 pfet L=4U W=4U AS=3.2P AD=3.2P PS=9.6U PD=9.6U
* device instance $127 r0 *1 185.6,39 pfet
M$127 PG PB VDD \$92 pfet L=4U W=10U AS=8P AD=8P PS=21.6U PD=21.6U
* device instance $128 r0 *1 205.1,39 pfet
M$128 PB PB VDD \$92 pfet L=4U W=10U AS=8P AD=8P PS=21.6U PD=21.6U
* device instance $129 r0 *1 217.3,34.5 pfet
M$129 PCAS PCAS VDD \$92 pfet L=8U W=1U AS=0.8P AD=0.8P PS=3.6U PD=3.6U
* device instance $130 r0 *1 223.65,35 pfet
M$130 ENB EN|RESETn VDD \$92 pfet L=0.5U W=2U AS=1.6P AD=1.6P PS=5.6U PD=5.6U
* device instance $131 r0 *1 232.6,34.5 pfet
M$131 ND PB VDD \$92 pfet L=8U W=1U AS=0.8P AD=0.8P PS=3.6U PD=3.6U
* device instance $132 r0 *1 247.9,34.5 pfet
M$132 NR PG VDD \$92 pfet L=4U W=1U AS=0.8P AD=0.8P PS=3.6U PD=3.6U
* device instance $133 r0 *1 258.95,36 pfet
M$133 PG EN|RESETn VDD \$92 pfet L=0.5U W=4U AS=3.2P AD=3.2P PS=9.6U PD=9.6U
* device instance $134 r0 *1 523.35,-396 pfet
M$134 BIAS_OKB BIAS_OK VDD \$49 pfet L=0.5U W=2U AS=1P AD=1.6P PS=5U PD=5.6U
* device instance $135 r0 *1 505,81 bjt
Q$135 vsubs \$116 NC bjt AE=100P PE=40U AB=144P PB=48U AC=144P PC=48U NE=1
* device instance $136 r0 *1 519,81 bjt
Q$136 vsubs \$116 NC bjt AE=100P PE=40U AB=144P PB=48U AC=144P PC=48U NE=1
* device instance $137 r0 *1 533,81 bjt
Q$137 vsubs \$116 NC bjt AE=100P PE=40U AB=144P PB=48U AC=144P PC=48U NE=1
* device instance $138 r0 *1 505,95 bjt
Q$138 vsubs \$116 NC bjt AE=100P PE=40U AB=144P PB=48U AC=144P PC=48U NE=1
* device instance $139 r0 *1 519,95 bjt
Q$139 vsubs \$116 NA bjt AE=100P PE=40U AB=144P PB=48U AC=144P PC=48U NE=1
* device instance $140 r0 *1 533,95 bjt
Q$140 vsubs \$116 NC bjt AE=100P PE=40U AB=144P PB=48U AC=144P PC=48U NE=1
* device instance $141 r0 *1 505,109 bjt
Q$141 vsubs \$116 NC bjt AE=100P PE=40U AB=144P PB=48U AC=144P PC=48U NE=1
* device instance $142 r0 *1 519,109 bjt
Q$142 vsubs \$116 NC bjt AE=100P PE=40U AB=144P PB=48U AC=144P PC=48U NE=1
* device instance $143 r0 *1 533,109 bjt
Q$143 vsubs \$116 NC bjt AE=100P PE=40U AB=144P PB=48U AC=144P PC=48U NE=1
* device instance $144 r0 *1 888.8,-362.3 cap_mim_2f0_m4m5_noshield
C$144 \$53 \$52 2.42e-13 cap_mim_2f0_m4m5_noshield
* device instance $145 r0 *1 835.7,-353.8 cap_mim_2f0_m4m5_noshield
C$145 \$61 \$59 1.568e-12 cap_mim_2f0_m4m5_noshield
* device instance $146 r0 *1 866.5,-353.8 cap_mim_2f0_m4m5_noshield
C$146 \$58 \$56 1.568e-12 cap_mim_2f0_m4m5_noshield
* device instance $147 r0 *1 835.7,-323 cap_mim_2f0_m4m5_noshield
C$147 \$66 \$65 1.568e-12 cap_mim_2f0_m4m5_noshield
* device instance $148 r0 *1 866.5,-323 cap_mim_2f0_m4m5_noshield
C$148 \$64 \$62 1.568e-12 cap_mim_2f0_m4m5_noshield
* device instance $149 r0 *1 307,92.867 ppolyf_u
R$149 NB \$133 vsubs 10453.625 ppolyf_u
* device instance $150 r0 *1 310,92.867 ppolyf_u
R$150 NC \$133 vsubs 10453.625 ppolyf_u
* device instance $151 r0 *1 313,90.762 ppolyf_u
R$151 NA \$131 vsubs 9716.875 ppolyf_u
* device instance $152 r0 *1 316,90.762 ppolyf_u
R$152 CTAT \$131 vsubs 9716.875 ppolyf_u
* device instance $153 r0 *1 319,113 ppolyf_u
R$153 NZ \$134 vsubs 17500 ppolyf_u
* device instance $154 r0 *1 322,113 ppolyf_u
R$154 \$93 \$134 vsubs 17500 ppolyf_u
* device instance $155 r0 *1 325,113 ppolyf_u
R$155 \$93 \$135 vsubs 17500 ppolyf_u
* device instance $156 r0 *1 328,113 ppolyf_u
R$156 \$94 \$135 vsubs 17500 ppolyf_u
* device instance $157 r0 *1 331,113 ppolyf_u
R$157 \$94 \$136 vsubs 17500 ppolyf_u
* device instance $158 r0 *1 334,113 ppolyf_u
R$158 \$95 \$136 vsubs 17500 ppolyf_u
* device instance $159 r0 *1 337,113 ppolyf_u
R$159 \$95 \$137 vsubs 17500 ppolyf_u
* device instance $160 r0 *1 340,113 ppolyf_u
R$160 \$96 \$137 vsubs 17500 ppolyf_u
* device instance $161 r0 *1 343,113 ppolyf_u
R$161 \$96 \$138 vsubs 17500 ppolyf_u
* device instance $162 r0 *1 346,113 ppolyf_u
R$162 N2 \$138 vsubs 17500 ppolyf_u
* device instance $163 r0 *1 349,118.262 ppolyf_u
R$163 PTAT \$139 vsubs 19341.875 ppolyf_u
* device instance $164 r0 *1 352,118.262 ppolyf_u
R$164 \$97 \$139 vsubs 19341.875 ppolyf_u
* device instance $165 r0 *1 355,118.262 ppolyf_u
R$165 \$97 \$140 vsubs 19341.875 ppolyf_u
* device instance $166 r0 *1 358,118.262 ppolyf_u
R$166 \$98 \$140 vsubs 19341.875 ppolyf_u
* device instance $167 r0 *1 361,118.262 ppolyf_u
R$167 \$98 \$141 vsubs 19341.875 ppolyf_u
* device instance $168 r0 *1 364,118.262 ppolyf_u
R$168 \$99 \$141 vsubs 19341.875 ppolyf_u
* device instance $169 r0 *1 367,118.262 ppolyf_u
R$169 \$99 \$142 vsubs 19341.875 ppolyf_u
* device instance $170 r0 *1 370,118.262 ppolyf_u
R$170 \$100 \$142 vsubs 19341.875 ppolyf_u
* device instance $171 r0 *1 373,118.262 ppolyf_u
R$171 \$100 \$143 vsubs 19341.875 ppolyf_u
* device instance $172 r0 *1 376,118.262 ppolyf_u
R$172 \$101 \$143 vsubs 19341.875 ppolyf_u
* device instance $173 r0 *1 379,118.262 ppolyf_u
R$173 \$101 \$144 vsubs 19341.875 ppolyf_u
* device instance $174 r0 *1 382,118.262 ppolyf_u
R$174 \$102 \$144 vsubs 19341.875 ppolyf_u
* device instance $175 r0 *1 385,118.262 ppolyf_u
R$175 \$102 \$145 vsubs 19341.875 ppolyf_u
* device instance $176 r0 *1 388,118.262 ppolyf_u
R$176 \$103 \$145 vsubs 19341.875 ppolyf_u
* device instance $177 r0 *1 391,118.262 ppolyf_u
R$177 \$103 \$146 vsubs 19341.875 ppolyf_u
* device instance $178 r0 *1 394,118.262 ppolyf_u
R$178 \$104 \$146 vsubs 19341.875 ppolyf_u
* device instance $179 r0 *1 397,118.262 ppolyf_u
R$179 \$104 \$147 vsubs 19341.875 ppolyf_u
* device instance $180 r0 *1 400,118.262 ppolyf_u
R$180 \$105 \$147 vsubs 19341.875 ppolyf_u
* device instance $181 r0 *1 403,118.262 ppolyf_u
R$181 \$105 \$148 vsubs 19341.875 ppolyf_u
* device instance $182 r0 *1 406,118.262 ppolyf_u
R$182 \$106 \$148 vsubs 19341.875 ppolyf_u
* device instance $183 r0 *1 409,118.262 ppolyf_u
R$183 \$106 \$149 vsubs 19341.875 ppolyf_u
* device instance $184 r0 *1 412,118.262 ppolyf_u
R$184 \$107 \$149 vsubs 19341.875 ppolyf_u
* device instance $185 r0 *1 415,118.262 ppolyf_u
R$185 \$107 \$150 vsubs 19341.875 ppolyf_u
* device instance $186 r0 *1 418,118.262 ppolyf_u
R$186 T5 \$150 vsubs 19341.875 ppolyf_u
* device instance $187 r0 *1 421,120.427 ppolyf_u
R$187 T5 \$151 vsubs 20099.625 ppolyf_u
* device instance $188 r0 *1 424,120.427 ppolyf_u
R$188 T4 \$151 vsubs 20099.625 ppolyf_u
* device instance $189 r0 *1 427,91.672 ppolyf_u
R$189 T4 \$132 vsubs 10035.375 ppolyf_u
* device instance $190 r0 *1 430,91.672 ppolyf_u
R$190 T3 \$132 vsubs 10035.375 ppolyf_u
* device instance $191 r0 *1 433,77.295 ppolyf_u
R$191 T3 \$123 vsubs 5003.25 ppolyf_u
* device instance $192 r0 *1 436,77.295 ppolyf_u
R$192 T2 \$123 vsubs 5003.25 ppolyf_u
* device instance $193 r0 *1 439,70.105 ppolyf_u
R$193 T2 \$119 vsubs 2486.75 ppolyf_u
* device instance $194 r0 *1 442,70.105 ppolyf_u
R$194 T1 \$119 vsubs 2486.75 ppolyf_u
* device instance $195 r0 *1 445,66.507 ppolyf_u
R$195 T1 \$114 vsubs 1227.625 ppolyf_u
* device instance $196 r0 *1 448,66.507 ppolyf_u
R$196 T0 \$114 vsubs 1227.625 ppolyf_u
* device instance $197 r0 *1 451,64.712 ppolyf_u
R$197 T0 \$113 vsubs 599.375 ppolyf_u
* device instance $198 r0 *1 454,64.712 ppolyf_u
R$198 VSS \$113 vsubs 599.375 ppolyf_u
.ENDS temp_por_top
