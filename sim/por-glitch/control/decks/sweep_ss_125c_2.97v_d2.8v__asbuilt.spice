* por-glitch depth/duration sweep @ ss / 125 C / 2.97 V / floor 2.8 V / hold 100 ns / arm=asbuilt -- GENERATED by run_depth_sweep.py, do not edit
* pdk=gf180mcuD@c6d73a35f524070e85faff4a6a9eef49553ebc2b

.param vdd_val=2.97
.param glitch_v=2.8
.param t_fall=0.0200001
.param t_hold=0.0200002
.param t_rise=0.0200003
.param stop_s=0.03

.include "/Users/rwalters/.volare/gf180mcuD/libs.tech/ngspice/design.ngspice"
.lib "/Users/rwalters/.volare/gf180mcuD/libs.tech/ngspice/sm141064.ngspice" ss
.lib "/Users/rwalters/.volare/gf180mcuD/libs.tech/ngspice/sm141064.ngspice" res_ss
.lib "/Users/rwalters/.volare/gf180mcuD/libs.tech/ngspice/sm141064.ngspice" bjt_ss
.lib "/Users/rwalters/.volare/gf180mcuD/libs.tech/ngspice/sm141064.ngspice" diode_ss
.lib "/Users/rwalters/.volare/gf180mcuD/libs.tech/ngspice/sm141064.ngspice" moscap_ss
.lib "/Users/rwalters/.volare/gf180mcuD/libs.tech/ngspice/sm141064.ngspice" mimcap_ss

.temp 125.0
.options reltol=1e-5
.options abstol=1e-15
.options vntol=1e-9

.include "../depth_sweep.spice"
.include "sweep_dut_asbuilt.spice"

.tran 20u {stop_s}

.control
set numdgt=10
set noaskquit
run
wrdata ss_125c_2.97v_d2.8v__asbuilt.csv v(vdd) v(xdut.por_raw) v(xdut.xpor.pgdg) v(xdut.vref) v(resetn) v(xdut.xpor.tim)
.endc
.end
