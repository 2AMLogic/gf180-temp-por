* tb_por_threshold_mc_postlayout -- GENERATED by sim/build_tb.py
* Do not edit. Sources:
*   sim/por-threshold-mc/testbench/stimulus.spice
*   layout/postlayout/por_comparator.spice  (sha256 b6875e1abe48b7722efe59150dd9fefc0f2a0fb7c569851aedb1181217d1e404)
* Regenerate with:
*   python3 sim/build_tb.py

* por-threshold-mc -- stimulus half of the testbench fragment.
*
* The other half is a verbatim copy of design/netlist/por_comparator.spice,
* appended by sim/build_tb.py to produce tb_por_threshold_mc.spice. Edit
* THIS file (or the schematic), never the generated fragment.
*
* Netlist FRAGMENT: no .include / .lib / .temp / .control / .end -- the
* harness owns those. Parameters supplied by sim/harness/montecarlo.py:
* vdd_val, vdd_nom, temp_c (plus .option seed=/.param sw_stat_mismatch=1).
*
* WHAT THIS EXPERIMENT SUBSTANTIATES (issue #15)
*
* spec/target-spec.md#por-vth-rise, #por-vth-fall, #por-hysteresis -- the
* LOCAL MISMATCH share (comparator input-pair offset, divider-ratio
* mismatch) of all three [3sigma] rows, at each row's own named binding
* corner (see the per-row "binds at" text in spec/target-spec.md section 4.1
* and sim/por-vth/'s measured record, which is where these five distinct
* (process, temperature, rail) binding points come from). Complements the
* deterministic corner-sweep systematic/corner share sim/por-vth/ (#14)
* already published on the full assembly.
*
* IDEALISED IBIAS/VREF, SAME CELL sim/por-comparator-designer-check/ uses --
* deliberate, not a cut corner, for the identical reason
* sim/temp-accuracy-mc/'s stimulus documents: the comparator's own offset and
* the divider's own ratio mismatch are properties of THIS cell's devices,
* not of bias_core's startup dynamics, so isolating them on the cheaper
* idealised-bias cell-level testbench is the right level to run N=500 per
* binding point x 5 binding points = 2500 ngspice invocations at. The
* assembled-path corner sweep (#14, sim/por-vth/) remains the authority for
* the process/temperature/rail axis; this experiment adds the local-mismatch
* axis on top, at #14's own measured binding points.
*
* ONE INSTANCE, ONE TRIANGLE WAVE -- load-bearing, not a simplification.
* sim/por-comparator-designer-check/ uses TWO instances (xup/xdn) for its
* rise/fall pair because with mismatch off (sw_stat_mismatch=0 there) the two
* instances are electrically identical, so "same corner point" is exact
* either way. Here mismatch is ON: two separate instances would draw TWO
* INDEPENDENT random mismatch realisations, so a "hysteresis" computed as
* their difference would be measuring cross-die spread dressed up as a
* same-die quantity -- exactly backwards from spec/target-spec.md's own
* framing ("Both edges measured at the same corner point (hysteresis is a
* same-die difference, not a corner-to-corner one)"). One instance, ramped
* up then down, guarantees both edges see the identical mismatch draw by
* construction.
*
* RAMP RATE: fast. Unlike sim/por-vth/'s full-assembly deck, IBIAS and VREF
* here are idealised DC sources with no startup/settling dynamics to wait
* out (matching sim/por-comparator-designer-check/'s own choice of a 10 ms
* single-edge ramp) -- there is no bias_core-starved-loop lag this comparator
* has to be given time to settle out of. 0 -> vdd_val in 5 ms, held to
* 10 ms, vdd_val -> 0 by 15 ms: comfortably inside the ratified
* por-ramp-rate envelope and enough for BIAS_OK-tied-high measurement of
* both crossings in one transient, at roughly 1 second of ngspice time per
* sample (see sim/harness montecarlo.py's module docstring for the budget
* this was sized against).
*
* BIAS_OK tied high throughout (including the 0 V endpoints), exactly as
* sim/por-comparator-designer-check/ does: this is the comparator's OWN
* threshold characteristic over its full input range, not a statement about
* when BIAS_OK is realistically valid (that ordering is #11/#14's job).

vsup vdd 0 pwl(0 0 5m {vdd_val} 10m {vdd_val} 15m 0)
vok bias_ok 0 dc {vdd_val}
vref vref 0 dc 1.2
ibref vdd ibias dc 500n
xdut vdd 0 ibias vref bias_ok por_raw por_comparator

* por_comparator -- post-layout netlist
* GENERATED by layout/postlayout.py -- do not edit.
*
* FROM THE LAYOUT: every device and its dimensions, the whole
*   topology, and first-order interconnect R/C on 15/18 nets
*   (sigma 473.0 fF). klt 0.2.0, deck gf180mcu,
*   GDS sha256 45b4b14914c4e651...
* Net names are the schematic's, restored through klt lvs's own net
*   correspondence -- match, 18/18 nets, every one paired.
*
* NOT FROM THE LAYOUT -- see layout/postlayout/AUDIT.md:
*   3 body/plate net(s) tied to the net the schematic puts
*   them on. The extraction deck's connectivity stack does not reach
*   an Nwell, a substrate ring, a bipolar base well or a MiM plate,
*   so they extract isolated and would otherwise float.
*   No ideal device: every golden device is drawn.
*
.subckt por_comparator VDD VSS IBIAS VREF BIAS_OK POR_RAW

* --- drawn devices ---
X1 TN NBG VSS VSS nfet_03v3 L=10u W=1u nf=1 ad=0.8p as=0.8p pd=3.6u ps=3.6u m=1
X2 IBIAS BIAS_OKB VSS VSS nfet_03v3 L=1u W=1u nf=1 ad=0.8p as=0.8p pd=3.6u ps=3.6u m=1
X3 N1 CMPO VSS VSS nfet_03v3 L=0.5u W=1u nf=1 ad=0.8p as=0.8p pd=3.6u ps=3.6u m=1
X4 POR_RAW N1 VSS VSS nfet_03v3 L=0.5u W=1u nf=1 ad=0.8p as=0.8p pd=3.6u ps=3.6u m=1
X5 BIAS_OKB BIAS_OK VSS VSS nfet_03v3 L=0.5u W=1u nf=1 ad=0.8p as=0.5p pd=3.6u ps=3u m=1
X6 NA SNS TN VSS nfet_03v3 L=1u W=2u nf=1 ad=1.6p as=1.6p pd=5.6u ps=5.6u m=1
X7 CMPO VREF TN VSS nfet_03v3 L=1u W=2u nf=1 ad=1.6p as=1.6p pd=5.6u ps=5.6u m=1
X8 IBIAS NBG VSS VSS nfet_03v3 L=2u W=2u nf=1 ad=1.6p as=1.6p pd=5.6u ps=5.6u m=1
X9 IBIAS BIAS_OK NBG VSS nfet_03v3 L=0.5u W=2u nf=1 ad=1.6p as=1.6p pd=5.6u ps=5.6u m=1
X10 NBG BIAS_OKB VSS VSS nfet_03v3 L=0.5u W=2u nf=1 ad=1.6p as=1.6p pd=5.6u ps=5.6u m=1
X11 CMPO BIAS_OKB VSS VSS nfet_03v3 L=1u W=2u nf=1 ad=1.6p as=1.6p pd=5.6u ps=5.6u m=1
X12 SNSB N1 VSS VSS nfet_03v3 L=0.5u W=10u nf=1 ad=8p as=8p pd=21.6u ps=21.6u m=1
X13 N1 CMPO VDD VDD pfet_03v3 L=0.5u W=2u nf=1 ad=1.6p as=1.6p pd=5.6u ps=5.6u m=1
X14 POR_RAW N1 VDD VDD pfet_03v3 L=0.5u W=2u nf=1 ad=1.6p as=1.6p pd=5.6u ps=5.6u m=1
X15 NA NA VDDA VDD pfet_03v3 L=1u W=4u nf=1 ad=3.2p as=3.2p pd=9.6u ps=9.6u m=1
X16 CMPO NA VDDA VDD pfet_03v3 L=1u W=4u nf=1 ad=3.2p as=3.2p pd=9.6u ps=9.6u m=1
X17 VDDA BIAS_OKB VDD VDD pfet_03v3 L=0.5u W=4u nf=1 ad=3.2p as=3.2p pd=9.6u ps=9.6u m=1
X18 BIAS_OKB BIAS_OK VDD VDD pfet_03v3 L=0.5u W=2u nf=1 ad=1.6p as=1p pd=5.6u ps=5u m=1
X19 SNS VDD VSS ppolyf_u_3k r_width=2u r_length=7897.44u
X20 SNSB SNS VSS ppolyf_u_3k r_width=2u r_length=6769.23u
X21 VSS SNSB VSS ppolyf_u_3k r_width=2u r_length=775u

R_10 SNS SNS__par 1410.6865
C_10 SNS__par VSS 2.5945833e-14
R_12 NBG NBG__par 1516.9554
C_12 NBG__par VSS 2.1326008e-14
R_14 SNSB SNSB__par 1330.8009
C_14 SNSB__par VSS 1.7531363e-14
R_3 VDDA VDDA__par 1263.8244
C_3 VDDA__par VSS 1.4679011e-14
R_4 NA NA__par 1384.846
C_4 NA__par VSS 1.5868526e-14
R_5 CMPO CMPO__par 1382.1249
C_5 CMPO__par VSS 1.7766709e-14
R_7 N1 N1__par 1437.8825
C_7 N1__par VSS 1.7866109e-14
R_9 TN TN__par 1261.1261
C_9 TN__par VSS 1.3588667e-14
RBIAS_OK BIAS_OK BIAS_OK__par 1452.1675
CBIAS_OK BIAS_OK__par VSS 1.5015489e-14
RBIAS_OKB BIAS_OKB BIAS_OKB__par 1631.1837
CBIAS_OKB BIAS_OKB__par VSS 2.1659338e-14
RIBIAS IBIAS IBIAS__par 1265.9835
CIBIAS IBIAS__par VSS 1.5551286e-14
RPOR_RAW POR_RAW POR_RAW__par 1260.5254
CPOR_RAW POR_RAW__par VSS 1.3389027e-14
RVDD VDD VDD__par 74.7605
CVDD VDD__par VSS 5.225586e-14
RVREF VREF VREF__par 1314.9134
CVREF VREF__par VSS 1.1576327e-14
RVSS VSS VSS__par 129.7465
CVSS VSS__par VSS 1.989616e-13
.ends por_comparator
