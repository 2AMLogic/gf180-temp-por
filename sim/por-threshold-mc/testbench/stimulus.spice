* por-threshold-mc -- stimulus half of the testbench fragment.
*
* The other half is a verbatim copy of design/netlist/por_comparator.spice,
* appended by sim/build_tb.py to produce tb_por_threshold_mc.spice. Edit
* THIS file (or the schematic), never the generated fragment.
*
* Netlist FRAGMENT: no .include / .lib / .temp / .control / .end -- the
* harness owns those. Parameters supplied by sim/harness/montecarlo.py:
* vdd_val, vdd_nom, temp_c (plus .option seed=/.param sw_stat_mismatch=1).
*
* WHAT THIS EXPERIMENT SUBSTANTIATES (issue #15)
*
* spec/target-spec.md#por-vth-rise, #por-vth-fall, #por-hysteresis -- the
* LOCAL MISMATCH share (comparator input-pair offset, divider-ratio
* mismatch) of all three [3sigma] rows, at each row's own named binding
* corner (see the per-row "binds at" text in spec/target-spec.md section 4.1
* and sim/por-vth/'s measured record, which is where these five distinct
* (process, temperature, rail) binding points come from). Complements the
* deterministic corner-sweep systematic/corner share sim/por-vth/ (#14)
* already published on the full assembly.
*
* IDEALISED IBIAS/VREF, SAME CELL sim/por-comparator-designer-check/ uses --
* deliberate, not a cut corner, for the identical reason
* sim/temp-accuracy-mc/'s stimulus documents: the comparator's own offset and
* the divider's own ratio mismatch are properties of THIS cell's devices,
* not of bias_core's startup dynamics, so isolating them on the cheaper
* idealised-bias cell-level testbench is the right level to run N=500 per
* binding point x 5 binding points = 2500 ngspice invocations at. The
* assembled-path corner sweep (#14, sim/por-vth/) remains the authority for
* the process/temperature/rail axis; this experiment adds the local-mismatch
* axis on top, at #14's own measured binding points.
*
* ONE INSTANCE, ONE TRIANGLE WAVE -- load-bearing, not a simplification.
* sim/por-comparator-designer-check/ uses TWO instances (xup/xdn) for its
* rise/fall pair because with mismatch off (sw_stat_mismatch=0 there) the two
* instances are electrically identical, so "same corner point" is exact
* either way. Here mismatch is ON: two separate instances would draw TWO
* INDEPENDENT random mismatch realisations, so a "hysteresis" computed as
* their difference would be measuring cross-die spread dressed up as a
* same-die quantity -- exactly backwards from spec/target-spec.md's own
* framing ("Both edges measured at the same corner point (hysteresis is a
* same-die difference, not a corner-to-corner one)"). One instance, ramped
* up then down, guarantees both edges see the identical mismatch draw by
* construction.
*
* RAMP RATE: fast. Unlike sim/por-vth/'s full-assembly deck, IBIAS and VREF
* here are idealised DC sources with no startup/settling dynamics to wait
* out (matching sim/por-comparator-designer-check/'s own choice of a 10 ms
* single-edge ramp) -- there is no bias_core-starved-loop lag this comparator
* has to be given time to settle out of. 0 -> vdd_val in 5 ms, held to
* 10 ms, vdd_val -> 0 by 15 ms: comfortably inside the ratified
* por-ramp-rate envelope and enough for BIAS_OK-tied-high measurement of
* both crossings in one transient, at roughly 1 second of ngspice time per
* sample (see sim/harness montecarlo.py's module docstring for the budget
* this was sized against).
*
* BIAS_OK tied high throughout (including the 0 V endpoints), exactly as
* sim/por-comparator-designer-check/ does: this is the comparator's OWN
* threshold characteristic over its full input range, not a statement about
* when BIAS_OK is realistically valid (that ordering is #11/#14's job).

vsup vdd 0 pwl(0 0 5m {vdd_val} 10m {vdd_val} 15m 0)
vok bias_ok 0 dc {vdd_val}
vref vref 0 dc 1.2
ibref vdd ibias dc 500n
xdut vdd 0 ibias vref bias_ok por_raw por_comparator
