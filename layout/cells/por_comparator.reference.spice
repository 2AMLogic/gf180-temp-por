* por_comparator -- klt lvs reference netlist
* generated by layout/lvs_reference.py from design/netlist/por_comparator.spice
* Do not edit: edit the schematic, re-run design/netlist.py, re-run this.
.SUBCKT por_comparator BIAS_OK BIAS_OKB IBIAS POR_RAW VDD VREF VSS
M1 BIAS_OKB BIAS_OK VSS VSS nfet L=0.5U W=1U
M2 BIAS_OKB BIAS_OK VDD VDD pfet L=0.5U W=2U
M3 NA NA VDDA VDD pfet L=1U W=4U
M4 CMPO NA VDDA VDD pfet L=1U W=4U
M5 VDDA BIAS_OKB VDD VDD pfet L=0.5U W=4U
M6 N1 CMPO VDD VDD pfet L=0.5U W=2U
M7 POR_RAW N1 VDD VDD pfet L=0.5U W=2U
M8 NA SNS TN VSS nfet L=1U W=2U
M9 CMPO VREF TN VSS nfet L=1U W=2U
M10 TN NBG VSS VSS nfet L=10U W=1U
M11 IBIAS NBG VSS VSS nfet L=2U W=2U
M12 IBIAS BIAS_OK NBG VSS nfet L=0.5U W=2U
M13 NBG BIAS_OKB VSS VSS nfet L=0.5U W=2U
M14 IBIAS BIAS_OKB VSS VSS nfet L=1U W=1U
M15 SNSB N1 VSS VSS nfet L=0.5U W=10U
M16 CMPO BIAS_OKB VSS VSS nfet L=1U W=2U
M17 N1 CMPO VSS VSS nfet L=0.5U W=1U
M18 POR_RAW N1 VSS VSS nfet L=0.5U W=1U
R19 SNS VDD VSS 3948720 ppolyf_u_1k
R20 SNSB SNS VSS 3384615 ppolyf_u_1k
R21 VSS SNSB VSS 387500 ppolyf_u_1k
.ENDS por_comparator
