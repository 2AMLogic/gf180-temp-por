* bias_core -- klt lvs reference netlist
* generated by layout/lvs_reference.py from design/netlist/bias_core.spice
* Do not edit: edit the schematic, re-run design/netlist.py, re-run this.
.SUBCKT bias_core BIAS_OK IBIAS VDD VREF VSS vsubs
M1 NBG NBG VSS vsubs nfet L=4U W=2U
M2 NA PG VDD NW1 pfet L=4U W=8U
M3 NBTOP PG VDD NW1 pfet L=4U W=8U
M4 VREF PG VDD NW1 pfet L=4U W=8U
M5 NBG PG VDD NW1 pfet L=4U W=2U
M6 PB PB VDD NW1 pfet L=4U W=2U
M7 IBIAS PB VDD NW1 pfet L=4U W=40U
M8 NT PB VDD NW1 pfet L=4U W=2U
M9 N1 NA NT NW1 pfet L=4U W=16U
M10 N2 NB NT NW1 pfet L=4U W=16U
M11 PG PB VDD NW1 pfet L=4U W=2U
M12 NKM PB VDD NW1 pfet L=4U W=1U
M13 TOK PB VDD NW1 pfet L=4U W=1U
M14 NOKO NA TOK NW1 pfet L=4U W=8U
M15 NOKL NBTOP TOK NW1 pfet L=4U W=8U
M16 NOKX PB VDD NW1 pfet L=4U W=1U
M17 BIAS_OK NOKX VDD NW1 pfet L=4U W=1U
M18 PB NBG VSS vsubs nfet L=4U W=2U
M19 N1 N1 VSS vsubs nfet L=8U W=4U
M20 N2 N1 VSS vsubs nfet L=8U W=4U
M21 PG N2 VSS vsubs nfet L=8U W=8U
M22 VDD VDD KS1 vsubs nfet L=8U W=1U
M23 KS1 KS1 KS2 vsubs nfet L=8U W=1U
M24 KS2 KS2 KS3 vsubs nfet L=8U W=1U
M25 KS3 KS3 KS4 vsubs nfet L=8U W=1U
M26 KS4 KS4 NKG vsubs nfet L=8U W=1U
M27 NKM NKM VSS vsubs nfet L=4U W=2U
M28 NKG NKM VSS vsubs nfet L=4U W=8U
M29 PG NKG VSS vsubs nfet L=4U W=1U
M30 NOKL NOKL VSS vsubs nfet L=4U W=2U
M31 NOKO NOKL VSS vsubs nfet L=4U W=2U
M32 NOKO NKG VSS vsubs nfet L=1U W=2U
M33 NOKX NOKO VSS vsubs nfet L=4U W=2U
M34 BIAS_OK NOKX VSS vsubs nfet L=0.5U W=4U
R35 NBTOP XRT.1 vsubs 4375 ppolyf_u_1k
R36 XRT.1 NB vsubs 4375 ppolyf_u_1k
R37 NB XR1.1 vsubs 87500 ppolyf_u_1k
R38 XR1.1 EC vsubs 87500 ppolyf_u_1k
R39 VREF XR2.1 vsubs 128250 ppolyf_u_1k
R40 XR2.1 XR2.2 vsubs 128250 ppolyf_u_1k
R41 XR2.2 XR2.3 vsubs 128250 ppolyf_u_1k
R42 XR2.3 XR2.4 vsubs 128250 ppolyf_u_1k
R43 XR2.4 XR2.5 vsubs 128250 ppolyf_u_1k
R44 XR2.5 XR2.6 vsubs 128250 ppolyf_u_1k
R45 XR2.6 XR2.7 vsubs 128250 ppolyf_u_1k
R46 XR2.7 XR2.8 vsubs 128250 ppolyf_u_1k
R47 XR2.8 XR2.9 vsubs 128250 ppolyf_u_1k
R48 XR2.9 XR2.10 vsubs 128250 ppolyf_u_1k
R49 XR2.10 XR2.11 vsubs 128250 ppolyf_u_1k
R50 XR2.11 XR2.12 vsubs 128250 ppolyf_u_1k
R51 XR2.12 XR2.13 vsubs 128250 ppolyf_u_1k
R52 XR2.13 XR2.14 vsubs 128250 ppolyf_u_1k
R53 XR2.14 XR2.15 vsubs 128250 ppolyf_u_1k
R54 XR2.15 ER vsubs 128250 ppolyf_u_1k
R55 NZ XRZ.1 vsubs 127000 ppolyf_u_1k
R56 XRZ.1 XRZ.2 vsubs 127000 ppolyf_u_1k
R57 XRZ.2 XRZ.3 vsubs 127000 ppolyf_u_1k
R58 XRZ.3 N2 vsubs 127000 ppolyf_u_1k
Q59 vsubs NWQ NA bjt AE=100P
Q60 vsubs NWQ EC bjt AE=100P
Q61 vsubs NWQ EC bjt AE=100P
Q62 vsubs NWQ EC bjt AE=100P
Q63 vsubs NWQ EC bjt AE=100P
Q64 vsubs NWQ EC bjt AE=100P
Q65 vsubs NWQ EC bjt AE=100P
Q66 vsubs NWQ EC bjt AE=100P
Q67 vsubs NWQ EC bjt AE=100P
Q68 vsubs NWQ ER bjt AE=100P
C69 PG NZ 8e-13 cap_mim_2f0_m4m5_noshield
C70 VDD NOKX 7.2e-14 cap_mim_2f0_m4m5_noshield
.ENDS bias_core
