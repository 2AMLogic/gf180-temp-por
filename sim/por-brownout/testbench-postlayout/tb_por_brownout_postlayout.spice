* tb_por_brownout_postlayout -- GENERATED by sim/build_tb.py
* Do not edit. Sources:
*   sim/por-brownout/testbench/stimulus.spice
*   layout/postlayout/temp_por_top.spice  (sha256 983a403f540f6869a1297fc65d2bd74ad49aee3d8b6ca8c2f71219a0e5571c09)
* Regenerate with:
*   python3 sim/build_tb.py

* por-brownout -- stimulus half of the testbench fragment.
*
* The other half is a verbatim copy of design/netlist/temp_por_top.spice,
* appended by sim/build_tb.py to produce tb_por_brownout.spice. Edit THIS
* file (or the schematics), never the generated fragment.
*
* Netlist FRAGMENT: no .include / .lib / .temp / .control / .end -- the
* harness owns those. Parameters it supplies: vdd_val, vdd_nom, temp_c.
*
* WHAT THIS EXPERIMENT SUBSTANTIATES
*
* spec/target-spec.md#por-brownout: a dip that (a) takes VDD below
* VPOR-downarrow,min = 2.22 V and (b) stays below VPOR-downarrow for
* >= T_dip,min = 30 us must re-assert RESETn and regenerate the FULL
* [por-reset-pulse] (>=1 ms), on the full four-cell assembly with bias_core's
* real (starved, corner-dependent) recovery dynamics in the loop -- not the
* idealised-bias por_output_chain-only deglitch check
* sim/por-output-chain-deglitch/ already ran.
*
* T_dip,min WAS 10 us UNTIL DR-027 (#251). It is now 30 us: the deglitch dwell
* the cell actually achieves at the current the assembly really delivers to it
* (91.0251 nA, DR-024), measured across the full grid at both netlist levels
* by sim/por-output-chain-deglitch/control/run_dwell_sweep.py (slowest crossing
* 23.110 us, +29.8 % margin). This deck's dwell is UNCHANGED at 50 us, which is
* 1.67x the new value and still unambiguously qualifying under clause (b) --
* and the quantity clause (b) is actually written against here is the ~51 us
* the RAIL spends below VPOR-downarrow,min, not the programmed dwell. What did
* change is where resetn_floor_in_dip_mv is sampled: at 20.03 ms it sat 29 us
* into the dip, i.e. BEFORE a qualifying dwell had even elapsed under the new
* T_dip,min, so it now samples at 20.045 ms (44 us in). See tb.json.
*
* WHAT THIS DECK STILL DOES NOT DEMONSTRATE, AND WHY
*
* Clause (c) of the same row -- dVDD/dt|fall,max = 2.30 mV/us (DR-011, re-cost
* post-layout by DR-019) -- is violated by this deck by ~1000x: its dip edge is
* 1 us, i.e. 2300 mV/us. That is deliberate and predates DR-027: the 1 us edge
* is the edge the row's own root-cause investigation (#55) was run at, and
* sim/por-brownout/control/results.md part E shows that at THIS edge no dwell
* re-asserts RESETn inside the dip -- 5 ms (100x this deck's dwell, 167x
* T_dip,min) still does not. So this deck's FAIL is a clause-(c) failure, not a
* clause-(b) one, and re-costing T_dip,min neither fixes it nor is meant to.
* The assembly-level evidence that a dip meeting ALL THREE clauses re-asserts
* and regenerates the pulse is sim/por-brownout-slew/'s 2.30 mV/us rung
* (81/81 at both netlist levels), whose own dip holds the rail below
* VPOR-downarrow,min for ~1.1 ms -- 37x T_dip,min(new).
*
* It also carries the full-assembly confirmation of
* spec/target-spec.md#por-reset-pulse that #14 owes: the >=1 ms minimum was
* measured at the single-cell level by #12 (sim/por-output-chain-pulse/, min
* 4.21535 ms at ff/-40C/2.97V), and t_pulse_regen_ms below is the same
* quantity measured end to end on the assembled block, in the brownout
* context, at every corner -- including the observed MAXIMUM, which the
* ratified row explicitly asks #14 to record ("#14 records the observed max
* so a maximum can be added later on evidence").
*
* WHY A DEEP DIP: design/bias_core.md's "starved-loop window" documents that
* a FULL rail collapse leaves BIAS_OK reading a false valid for
* 326-1567 us while the reference loop crawls back (measured on bias_core
* alone, idealised load). This deck's dip goes to 1.0 V -- below every
* corner's comparator/reference operating floor (sim/por-comparator-
* designer-check/'s below-floor probes) -- so it exercises the SAME
* recovery path a full collapse does, but from a bounded starting point
* rather than 0 V, matching "brownout" rather than "power-cycle". If the
* starved-loop window shows up here as a longer-than-#12's-idealised-record
* reassert or release delay, that is the ALREADY-OWNED, ALREADY-TRACKED
* finding design/bias_core.md assigns to #1/#14 -- record it, do not
* root-cause it fresh (see design/bias_core.md, "The starved-loop window").
*
* TIMESTEP: the manifest asks for `tran 20u 55m`, i.e. a 20 us ceiling on the
* step in QUIET regions only. Both dip edges are PWL breakpoints ngspice
* lands on exactly, and the rail slews 2.0-2.6 V in 1 us across each of
* them, so local truncation error drives the step orders of magnitude below
* the ceiling through the whole disturbance -- which is where
* `t_reassert_us` (bounded at 50 us) is resolved. The ceiling only governs
* the two long static holds, where the full four-cell assembly would
* otherwise spend most of its ~12 ms-per-step solve cost resolving nothing.
*
* PAD LOAD: 1 pF plus a 1 Tohm DC leak on each of PTAT and CTAT, matching
* sim/temp-por-top-release/ and sim/temp-accuracy-vt/ exactly. The resistors
* are not a model of anything physical -- they are the DC reference the two
* analogue pads need in the state this deck spends most of its time in.
* While RESETn is asserted temp_core is disabled and its outputs are high
* impedance (DR-010's disabled-consumer contract), so without them PTAT and
* CTAT are capacitively coupled floating nodes, and ngspice's local
* truncation error control collapses the timestep trying to track them: an
* early revision of these decks, identical but for these four lines, ran
* >450 s of CPU per PVT point without completing, against ~36 s for the
* comparable 30 ms transient in sim/temp-por-top-release/. 1 Tohm at a
* ~1.3 V pad is 1.3 pA, four to five orders of magnitude below the block's
* own nanoamp-scale currents, so it references the node without loading it.
*
* ONE DUT, ONE TRAN, staged as a timeline (the multi-stage idiom
* sim/bias-core-startup/'s `xbo` branch already uses):
*
*   0    ->  1 ms   cold start: VDD ramps 0 -> vdd_val in 1 ms (2970-3630
*                    V/s, inside the ratified por-ramp-rate envelope and the
*                    exact cold start sim/temp-por-top-release/ validates
*                    releases correctly at all 81 points).
*    1   -> 20 ms   held at vdd_val -- rail settled, RESETn released.
*                    sim/temp-por-top-release/ measures release complete by
*                    16.95 ms at the slowest corner (ss/-40C/3.63V) off this
*                    same 1 ms ramp, so 20 ms leaves 3 ms of margin.
*   20   -> 20.001 ms   VDD dips from vdd_val to 1.0 V over 1 us.
*   20.001 -> 20.051 ms  held at 1.0 V for 50 us -- 1.67x T_dip,min = 30 us
*                    (DR-027, #251), and above the 6.14-23.11 us deglitch
*                    dwell sim/por-output-chain-deglitch/control/ measures at
*                    the cell level at the REAL delivered bias across both
*                    netlists, so this is unambiguously a QUALIFYING dip under
*                    clauses (a) and (b), not a glitch (that is
*                    sim/por-glitch/'s job). Clause (c) is a different matter
*                    -- see "WHAT THIS DECK STILL DOES NOT DEMONSTRATE" above.
*   20.051 -> 20.052 ms  VDD recovers from 1.0 V to vdd_val over 1 us.
*   20.052 -> 55 ms  held at vdd_val -- RESETn must have re-asserted during
*                    the dip and must now regenerate a full
*                    [por-reset-pulse] (>=1 ms) before releasing again. The
*                    35 ms of recovery observation is sized off the
*                    end-to-end release time sim/temp-por-top-release/
*                    measures on this same assembly (5.6-17.0 ms) plus the
*                    starved-loop window design/bias_core.md measures after
*                    a collapse (up to 1.57 ms) -- i.e. roughly 2x the
*                    slowest expected recovery, so a corner that takes
*                    longer than expected still lands inside the run and is
*                    measured rather than silently reported as "no data".

vsup vdd 0 PWL(
+ 0        0
+ 1m       {vdd_val}
+ 20m      {vdd_val}
+ 20.001m  1.0
+ 20.051m  1.0
+ 20.052m  {vdd_val}
+ 55m      {vdd_val}
+ )

Cpp ptat 0 1p
Cpc ctat 0 1p
Rlp ptat 0 1T
Rlc ctat 0 1T
Crn resetn 0 5p

xdut vdd 0 ptat ctat resetn temp_por_top

* temp_por_top -- post-layout netlist
* GENERATED by layout/postlayout.py -- do not edit.
*
* FROM THE LAYOUT: every device and its dimensions, the whole
*   topology, and first-order interconnect R/C on 136/136 nets
*   (sigma 7253.9 fF, of which 87.084 fF is net-to-net coupling).
*   One star per net: <net> is the hub, <net>__t<k> each device
*   terminal on it, R<net>_t<k> the arm between them.
*   klt 0.6.0, deck gf180mcu,
*   GDS sha256 77b86ce2189ae17d...
* Net names are the schematic's, restored through klt lvs's own net
*   correspondence -- match, 136/136 nets, every one paired.
*
* NOT FROM THE LAYOUT -- see layout/postlayout/AUDIT.md:
*   9 body/plate net(s) tied to the net the schematic puts
*   them on. The extraction deck's connectivity stack does not reach
*   an Nwell, a substrate ring, a bipolar base well or a MiM plate,
*   so they extract isolated and would otherwise float.
*   No ideal device: every golden device is drawn.
*
.subckt temp_por_top VDD VSS PTAT CTAT RESETn

* --- drawn devices ---
X1 xbias__NBG__t3 xbias__NBG__t2 VSS__t1 VSS__t186 nfet_03v3 L=4u W=2u nf=1 ad=1.6p as=1.6p pd=5.6u ps=5.6u m=1
X2 xbias__PB__t2 xbias__NBG__t1 VSS__t85 VSS__t187 nfet_03v3 L=4u W=2u nf=1 ad=1.6p as=1.6p pd=5.6u ps=5.6u m=1
X3 xbias__N1__t3 xbias__N1__t1 VSS__t2 VSS__t192 nfet_03v3 L=8u W=4u nf=1 ad=3.2p as=3.2p pd=9.6u ps=9.6u m=1
X4 xbias__N2__t0 xbias__N1__t2 VSS__t78 VSS__t193 nfet_03v3 L=8u W=4u nf=1 ad=3.2p as=3.2p pd=9.6u ps=9.6u m=1
X5 xbias__PG__t2 xbias__N2__t1 VSS__t3 VSS__t200 nfet_03v3 L=8u W=8u nf=1 ad=6.4p as=6.4p pd=17.6u ps=17.6u m=1
X6 VDD__t10 VDD__t11 xbias__KS1__t0 VSS__t202 nfet_03v3 L=8u W=1u nf=1 ad=0.8p as=0.8p pd=3.6u ps=3.6u m=1
X7 xbias__KS1__t2 xbias__KS1__t1 xbias__KS2__t0 VSS__t203 nfet_03v3 L=8u W=1u nf=1 ad=0.8p as=0.8p pd=3.6u ps=3.6u m=1
X8 xbias__KS2__t2 xbias__KS2__t1 xbias__KS3__t0 VSS__t204 nfet_03v3 L=8u W=1u nf=1 ad=0.8p as=0.8p pd=3.6u ps=3.6u m=1
X9 xbias__KS3__t2 xbias__KS3__t1 xbias__KS4__t0 VSS__t205 nfet_03v3 L=8u W=1u nf=1 ad=0.8p as=0.8p pd=3.6u ps=3.6u m=1
X10 xbias__KS4__t2 xbias__KS4__t1 xbias__NKG__t3 VSS__t206 nfet_03v3 L=8u W=1u nf=1 ad=0.8p as=0.8p pd=3.6u ps=3.6u m=1
X11 xbias__NKM__t3 xbias__NKM__t1 VSS__t87 VSS__t188 nfet_03v3 L=4u W=2u nf=1 ad=1.6p as=1.6p pd=5.6u ps=5.6u m=1
X12 xbias__NKG__t0 xbias__NKM__t2 VSS__t4 VSS__t207 nfet_03v3 L=4u W=8u nf=1 ad=6.4p as=6.4p pd=17.6u ps=17.6u m=1
X13 xbias__PG__t3 xbias__NKG__t1 VSS__t5 VSS__t208 nfet_03v3 L=4u W=1u nf=1 ad=0.8p as=0.8p pd=3.6u ps=3.6u m=1
X14 xbias__NOKL__t2 xbias__NOKL__t0 VSS__t86 VSS__t189 nfet_03v3 L=4u W=2u nf=1 ad=1.6p as=1.6p pd=5.6u ps=5.6u m=1
X15 xbias__NOKO__t2 xbias__NOKL__t1 VSS__t88 VSS__t190 nfet_03v3 L=4u W=2u nf=1 ad=1.6p as=1.6p pd=5.6u ps=5.6u m=1
X16 xbias__NOKO__t0 xbias__NKG__t2 VSS__t6 VSS__t209 nfet_03v3 L=1u W=2u nf=1 ad=1.6p as=1.6p pd=5.6u ps=5.6u m=1
X17 xbias__NOKX__t2 xbias__NOKO__t1 VSS__t89 VSS__t191 nfet_03v3 L=4u W=2u nf=1 ad=1.6p as=1.6p pd=5.6u ps=5.6u m=1
X18 BIAS_OK__t0 xbias__NOKX__t0 VSS__t7 VSS__t215 nfet_03v3 L=0.5u W=4u nf=1 ad=3.2p as=3.2p pd=9.6u ps=9.6u m=1
X19 xcmp__NA__t3 xcmp__SNS__t2 xcmp__TN__t1 VSS__t210 nfet_03v3 L=1u W=2u nf=1 ad=1.6p as=1.6p pd=5.6u ps=5.6u m=1
X20 xcmp__CMPO__t4 VREF__t1 xcmp__TN__t2 VSS__t211 nfet_03v3 L=1u W=2u nf=1 ad=1.6p as=1.6p pd=5.6u ps=5.6u m=1
X21 xcmp__TN__t0 xcmp__NBG__t0 VSS__t8 VSS__t216 nfet_03v3 L=10u W=1u nf=1 ad=0.8p as=0.8p pd=3.6u ps=3.6u m=1
X22 IBIAS__t1 xcmp__NBG__t1 VSS__t9 VSS__t217 nfet_03v3 L=2u W=2u nf=1 ad=1.6p as=1.6p pd=5.6u ps=5.6u m=1
X23 IBIAS__t8 BIAS_OK__t3 xcmp__NBG__t3 VSS__t220 nfet_03v3 L=0.5u W=2u nf=1 ad=1.6p as=1.6p pd=5.6u ps=5.6u m=1
X24 xcmp__NBG__t2 xcmp__BIAS_OKB__t1 VSS__t10 VSS__t221 nfet_03v3 L=0.5u W=2u nf=1 ad=1.6p as=1.6p pd=5.6u ps=5.6u m=1
X25 IBIAS__t2 xcmp__BIAS_OKB__t2 VSS__t11 VSS__t228 nfet_03v3 L=1u W=1u nf=1 ad=0.8p as=0.8p pd=3.6u ps=3.6u m=1
X26 xcmp__SNSB__t1 xcmp__N1__t1 VSS__t12 VSS__t234 nfet_03v3 L=0.5u W=10u nf=1 ad=8p as=8p pd=21.6u ps=21.6u m=1
X27 xcmp__CMPO__t3 xcmp__BIAS_OKB__t5 VSS__t76 VSS__t212 nfet_03v3 L=1u W=2u nf=1 ad=1.6p as=1.6p pd=5.6u ps=5.6u m=1
X28 xcmp__N1__t2 xcmp__CMPO__t1 VSS__t13 VSS__t236 nfet_03v3 L=0.5u W=1u nf=1 ad=0.8p as=0.8p pd=3.6u ps=3.6u m=1
X29 POR_RAW__t1 xcmp__N1__t3 VSS__t56 VSS__t237 nfet_03v3 L=0.5u W=1u nf=1 ad=0.8p as=0.8p pd=3.6u ps=3.6u m=1
X30 xcmp__BIAS_OKB__t3 BIAS_OK__t1 VSS__t14 VSS__t240 nfet_03v3 L=0.5u W=1u nf=1 ad=0.8p as=0.5p pd=3.6u ps=3u m=1
X31 IBIAS__t3 IBIAS__t4 VSS__t15 VSS__t241 nfet_03v3 L=4u W=4u nf=1 ad=3.2p as=3.2p pd=9.6u ps=9.6u m=1
X32 xpor__PDN__t0 IBIAS__t5 VSS__t16 VSS__t242 nfet_03v3 L=25u W=0.5u nf=1 ad=0.4p as=0.4p pd=2.6u ps=2.6u m=1
X33 xpor__NDL__t0 xpor__NDL__t1 VSS__t17 VSS__t243 nfet_03v3 L=10u W=2u nf=1 ad=1.6p as=1.6p pd=5.6u ps=5.6u m=1
X34 xpor__NDGN__t0 xpor__NDL__t2 VSS__t18 VSS__t244 nfet_03v3 L=10u W=10u nf=1 ad=8p as=8p pd=21.6u ps=21.6u m=1
X35 xpor__NDG__t3 POR_RAW__t2 xpor__NDGN__t1 VSS__t238 nfet_03v3 L=0.5u W=1u nf=1 ad=0.8p as=0.8p pd=3.6u ps=3.6u m=1
X36 xpor__PGDG__t3 xpor__NDG__t4 VSS__t66 VSS__t222 nfet_03v3 L=0.5u W=2u nf=1 ad=1.6p as=1.6p pd=5.6u ps=5.6u m=1
X37 xpor__PGDGB__t0 xpor__PGDG__t0 VSS__t19 VSS__t245 nfet_03v3 L=2u W=0.5u nf=1 ad=0.4p as=0.4p pd=2.6u ps=2.6u m=1
X38 xpor__TIM__t6 xpor__PGDGB__t2 VSS__t62 VSS__t229 nfet_03v3 L=1u W=1u nf=1 ad=0.8p as=0.8p pd=3.6u ps=3.6u m=1
X39 xpor__ND1__t0 xpor__NDL__t3 VSS__t20 VSS__t246 nfet_03v3 L=10u W=0.5u nf=1 ad=0.4p as=0.4p pd=2.6u ps=2.6u m=1
X40 xpor__TRIP__t1 xpor__ND1__t3 VSS__t59 VSS__t230 nfet_03v3 L=1u W=1u nf=1 ad=0.8p as=0.8p pd=3.6u ps=3.6u m=1
X41 xpor__ND1__t2 RESETn__t4 VSS__t61 VSS__t231 nfet_03v3 L=1u W=1u nf=1 ad=0.8p as=0.8p pd=3.6u ps=3.6u m=1
X42 xpor__RSTB__t3 xpor__TRIP__t2 xpor__NNAND__t1 VSS__t223 nfet_03v3 L=0.5u W=2u nf=1 ad=1.6p as=1.6p pd=5.6u ps=5.6u m=1
X43 xpor__NNAND__t0 xpor__PGDG__t2 VSS__t64 VSS__t224 nfet_03v3 L=0.5u W=2u nf=1 ad=1.6p as=1.6p pd=5.6u ps=5.6u m=1
X44 RESETn__t3 xpor__RSTB__t2 VSS__t58 VSS__t235 nfet_03v3 L=0.5u W=10u nf=1 ad=8p as=8p pd=21.6u ps=21.6u m=1
X45 VSS__t73 VSS__t71 VSS__t84 VSS__t194 nfet_03v3 L=8u W=4u nf=1 ad=3.2p as=3.2p pd=9.6u ps=9.6u m=1
X46 xtemp__N1__t5 xtemp__N1__t3 VSS__t83 VSS__t195 nfet_03v3 L=8u W=4u nf=1 ad=3.2p as=3.2p pd=9.6u ps=9.6u m=1
X47 xtemp__N2__t4 xtemp__N1__t2 VSS__t82 VSS__t196 nfet_03v3 L=8u W=4u nf=1 ad=3.2p as=3.2p pd=9.6u ps=9.6u m=1
X48 xtemp__N2__t3 xtemp__N1__t1 VSS__t81 VSS__t197 nfet_03v3 L=8u W=4u nf=1 ad=3.2p as=3.2p pd=9.6u ps=9.6u m=1
X49 xtemp__N1__t4 xtemp__N1__t0 VSS__t80 VSS__t198 nfet_03v3 L=8u W=4u nf=1 ad=3.2p as=3.2p pd=9.6u ps=9.6u m=1
X50 VSS__t72 VSS__t70 VSS__t79 VSS__t199 nfet_03v3 L=8u W=4u nf=1 ad=3.2p as=3.2p pd=9.6u ps=9.6u m=1
X51 xtemp__PG__t10 xtemp__N2__t2 VSS__t77 VSS__t201 nfet_03v3 L=8u W=8u nf=1 ad=6.4p as=6.4p pd=17.6u ps=17.6u m=1
X52 IBIAS__t6 xtemp__NBG__t0 VSS__t21 VSS__t247 nfet_03v3 L=2u W=4u nf=1 ad=3.2p as=3.2p pd=9.6u ps=9.6u m=1
X53 IBIAS__t7 RESETn__t5 xtemp__NBG__t4 VSS__t225 nfet_03v3 L=0.5u W=2u nf=1 ad=1.6p as=1.6p pd=5.6u ps=5.6u m=1
X54 xtemp__NBG__t3 xtemp__ENB__t3 VSS__t65 VSS__t226 nfet_03v3 L=0.5u W=2u nf=1 ad=1.6p as=1.6p pd=5.6u ps=5.6u m=1
X55 xtemp__PB__t5 xtemp__NBG__t2 VSS__t55 VSS__t248 nfet_03v3 L=2u W=4u nf=1 ad=3.2p as=3.2p pd=9.6u ps=9.6u m=1
X56 xtemp__PCAS__t0 xtemp__NBG__t1 VSS__t54 VSS__t249 nfet_03v3 L=2u W=4u nf=1 ad=3.2p as=3.2p pd=9.6u ps=9.6u m=1
X57 xtemp__ENB__t0 RESETn__t2 VSS__t57 VSS__t239 nfet_03v3 L=0.5u W=1u nf=1 ad=0.8p as=0.8p pd=3.6u ps=3.6u m=1
X58 xtemp__ND__t2 xtemp__NR__t2 VSS__t69 VSS__t218 nfet_03v3 L=2u W=2u nf=1 ad=1.6p as=1.6p pd=5.6u ps=5.6u m=1
X59 xtemp__PG__t0 xtemp__ND__t0 VSS__t22 VSS__t250 nfet_03v3 L=1u W=4u nf=1 ad=3.2p as=3.2p pd=9.6u ps=9.6u m=1
X60 xtemp__NR__t0 xtemp__NR__t1 VSS__t68 VSS__t219 nfet_03v3 L=2u W=2u nf=1 ad=1.6p as=1.6p pd=5.6u ps=5.6u m=1
X61 xtemp__ND__t3 xtemp__ENB__t4 VSS__t67 VSS__t227 nfet_03v3 L=0.5u W=2u nf=1 ad=1.6p as=1.6p pd=5.6u ps=5.6u m=1
X62 PTAT__t1 xtemp__ENB__t2 VSS__t63 VSS__t232 nfet_03v3 L=1u W=1u nf=1 ad=0.8p as=0.8p pd=3.6u ps=3.6u m=1
X63 CTAT__t1 xtemp__ENB__t1 VSS__t60 VSS__t233 nfet_03v3 L=1u W=1u nf=1 ad=0.8p as=0.8p pd=3.6u ps=3.6u m=1
X64 xtemp__N2__t1 xtemp__ENB__t6 VSS__t74 VSS__t213 nfet_03v3 L=1u W=2u nf=1 ad=1.6p as=1.6p pd=5.6u ps=5.6u m=1
X65 xtemp__NT__t1 xtemp__ENB__t7 VSS__t75 VSS__t214 nfet_03v3 L=1u W=2u nf=1 ad=1.6p as=1.6p pd=5.6u ps=5.6u m=1
X66 xtemp__T5__t0 VDD__t63 xtemp__T4__t0 VSS__t251 nfet_03v3 L=0.5u W=32u nf=1 ad=25.6p as=25.6p pd=65.6u ps=65.6u m=1
X67 xtemp__T3__t2 VSS__t24 xtemp__T2__t3 VSS__t252 nfet_03v3 L=0.5u W=32u nf=1 ad=25.6p as=25.6p pd=65.6u ps=65.6u m=1
X68 xtemp__T1__t2 VSS__t43 xtemp__T0__t3 VSS__t253 nfet_03v3 L=0.5u W=32u nf=1 ad=25.6p as=25.6p pd=65.6u ps=65.6u m=1
X69 xtemp__T0__t2 VSS__t44 VSS__t40 VSS__t254 nfet_03v3 L=0.5u W=32u nf=1 ad=25.6p as=25.6p pd=65.6u ps=65.6u m=1
X70 xtemp__T2__t2 VSS__t41 xtemp__T1__t3 VSS__t255 nfet_03v3 L=0.5u W=32u nf=1 ad=25.6p as=25.6p pd=65.6u ps=65.6u m=1
X71 xtemp__T4__t3 VSS__t42 xtemp__T3__t3 VSS__t256 nfet_03v3 L=0.5u W=32u nf=1 ad=25.6p as=25.6p pd=65.6u ps=65.6u m=1
X72 xbias__NA__t0 xbias__PG__t0 VDD__t1 VDD__t2 pfet_03v3 L=4u W=8u nf=1 ad=6.4p as=6.4p pd=17.6u ps=17.6u m=1
X73 xbias__NBTOP__t1 xbias__PG__t6 VDD__t109 VDD__t106 pfet_03v3 L=4u W=8u nf=1 ad=6.4p as=6.4p pd=17.6u ps=17.6u m=1
X74 VREF__t2 xbias__PG__t7 VDD__t110 VDD__t107 pfet_03v3 L=4u W=8u nf=1 ad=6.4p as=6.4p pd=17.6u ps=17.6u m=1
X75 xbias__NBG__t0 xbias__PG__t1 VDD__t3 VDD__t4 pfet_03v3 L=4u W=2u nf=1 ad=1.6p as=1.6p pd=5.6u ps=5.6u m=1
X76 xbias__PB__t5 xbias__PB__t6 VDD__t102 VDD__t99 pfet_03v3 L=4u W=2u nf=1 ad=1.6p as=1.6p pd=5.6u ps=5.6u m=1
X77 IBIAS__t0 xbias__PB__t0 VDD__t5 VDD__t6 pfet_03v3 L=4u W=40u nf=1 ad=32p as=32p pd=81.6u ps=81.6u m=1
X78 xbias__NT__t2 xbias__PB__t7 VDD__t103 VDD__t100 pfet_03v3 L=4u W=2u nf=1 ad=1.6p as=1.6p pd=5.6u ps=5.6u m=1
X79 xbias__N1__t0 xbias__NA__t1 xbias__NT__t0 VDD__t7 pfet_03v3 L=4u W=16u nf=1 ad=12.8p as=12.8p pd=33.6u ps=33.6u m=1
X80 xbias__N2__t3 xbias__NB__t2 xbias__NT__t1 VDD__t98 pfet_03v3 L=4u W=16u nf=1 ad=12.8p as=12.8p pd=33.6u ps=33.6u m=1
X81 xbias__PG__t5 xbias__PB__t8 VDD__t104 VDD__t101 pfet_03v3 L=4u W=2u nf=1 ad=1.6p as=1.6p pd=5.6u ps=5.6u m=1
X82 xbias__NKM__t0 xbias__PB__t1 VDD__t8 VDD__t9 pfet_03v3 L=4u W=1u nf=1 ad=0.8p as=0.8p pd=3.6u ps=3.6u m=1
X83 xbias__TOK__t0 xbias__PB__t3 VDD__t95 VDD__t91 pfet_03v3 L=4u W=1u nf=1 ad=0.8p as=0.8p pd=3.6u ps=3.6u m=1
X84 xbias__NOKO__t3 xbias__NA__t3 xbias__TOK__t1 VDD__t105 pfet_03v3 L=4u W=8u nf=1 ad=6.4p as=6.4p pd=17.6u ps=17.6u m=1
X85 xbias__NOKL__t3 xbias__NBTOP__t2 xbias__TOK__t2 VDD__t108 pfet_03v3 L=4u W=8u nf=1 ad=6.4p as=6.4p pd=17.6u ps=17.6u m=1
X86 xbias__NOKX__t3 xbias__PB__t4 VDD__t96 VDD__t92 pfet_03v3 L=4u W=1u nf=1 ad=0.8p as=0.8p pd=3.6u ps=3.6u m=1
X87 BIAS_OK__t4 xbias__NOKX__t4 VDD__t97 VDD__t93 pfet_03v3 L=4u W=1u nf=1 ad=0.8p as=0.8p pd=3.6u ps=3.6u m=1
X88 xcmp__NA__t0 xcmp__NA__t1 xcmp__VDDA__t0 VDD__t12 pfet_03v3 L=1u W=4u nf=1 ad=3.2p as=3.2p pd=9.6u ps=9.6u m=1
X89 xcmp__CMPO__t2 xcmp__NA__t2 xcmp__VDDA__t2 VDD__t86 pfet_03v3 L=1u W=4u nf=1 ad=3.2p as=3.2p pd=9.6u ps=9.6u m=1
X90 xcmp__VDDA__t1 xcmp__BIAS_OKB__t0 VDD__t13 VDD__t14 pfet_03v3 L=0.5u W=4u nf=1 ad=3.2p as=3.2p pd=9.6u ps=9.6u m=1
X91 xcmp__N1__t0 xcmp__CMPO__t0 VDD__t15 VDD__t16 pfet_03v3 L=0.5u W=2u nf=1 ad=1.6p as=1.6p pd=5.6u ps=5.6u m=1
X92 POR_RAW__t3 xcmp__N1__t4 VDD__t75 VDD__t72 pfet_03v3 L=0.5u W=2u nf=1 ad=1.6p as=1.6p pd=5.6u ps=5.6u m=1
X93 xpor__PDN__t1 xpor__PDN__t2 VDD__t17 VDD__t18 pfet_03v3 L=10u W=2u nf=1 ad=1.6p as=1.6p pd=5.6u ps=5.6u m=1
X94 xpor__NDL__t4 xpor__PDN__t6 VDD__t70 VDD__t69 pfet_03v3 L=10u W=2u nf=1 ad=1.6p as=1.6p pd=5.6u ps=5.6u m=1
X95 xpor__NDGP__t0 xpor__PDN__t3 VDD__t19 VDD__t20 pfet_03v3 L=10u W=10u nf=1 ad=8p as=8p pd=21.6u ps=21.6u m=1
X96 xpor__NTS__t0 xpor__PDN__t4 VDD__t21 VDD__t22 pfet_03v3 L=10u W=0.5u nf=1 ad=0.4p as=0.4p pd=2.6u ps=2.6u m=1
X97 xpor__TRIP__t0 xpor__PDN__t5 VDD__t67 VDD__t65 pfet_03v3 L=10u W=0.5u nf=1 ad=0.4p as=0.4p pd=2.6u ps=2.6u m=1
X98 xpor__NDG__t0 POR_RAW__t0 xpor__NDGP__t1 VDD__t23 pfet_03v3 L=0.5u W=1u nf=1 ad=0.8p as=0.8p pd=3.6u ps=3.6u m=1
X99 xpor__PGDG__t1 xpor__NDG__t1 VDD__t24 VDD__t25 pfet_03v3 L=2u W=0.5u nf=1 ad=0.4p as=0.4p pd=2.6u ps=2.6u m=1
X100 xpor__PGDGB__t3 xpor__PGDG__t5 VDD__t74 VDD__t71 pfet_03v3 L=0.5u W=2u nf=1 ad=1.6p as=1.6p pd=5.6u ps=5.6u m=1
X101 xpor__TIM__t5 xpor__PGDGB__t1 xpor__NTS__t1 VDD__t26 pfet_03v3 L=1u W=2u nf=1 ad=1.6p as=1.6p pd=5.6u ps=5.6u m=1
X102 xpor__ND1__t1 xpor__TIM__t0 VDD__t27 VDD__t64 pfet_03v3 L=1u W=2u nf=1 ad=1.6p as=1.6p pd=5.6u ps=5.6u m=1
X103 xpor__RSTB__t5 xpor__TRIP__t3 VDD__t82 VDD__t79 pfet_03v3 L=0.5u W=4u nf=1 ad=3.2p as=3.2p pd=9.6u ps=9.6u m=1
X104 xpor__RSTB__t4 xpor__PGDG__t4 VDD__t81 VDD__t78 pfet_03v3 L=0.5u W=4u nf=1 ad=3.2p as=3.2p pd=9.6u ps=9.6u m=1
X105 xpor__RSTB__t1 RESETn__t1 VDD__t68 VDD__t66 pfet_03v3 L=10u W=0.5u nf=1 ad=0.4p as=0.4p pd=2.6u ps=2.6u m=1
X106 RESETn__t0 xpor__RSTB__t0 VDD__t28 VDD__t29 pfet_03v3 L=1u W=1u nf=1 ad=0.8p as=0.8p pd=3.6u ps=3.6u m=1
X107 xtemp__NT__t2 xtemp__NT__t4 xtemp__NT__t9 xtemp__NT__t15 pfet_03v3 L=4u W=16u nf=1 ad=12.8p as=12.8p pd=33.6u ps=33.6u m=1
X108 xtemp__N1__t6 xtemp__NA__t4 xtemp__NT__t8 xtemp__NT__t14 pfet_03v3 L=4u W=16u nf=1 ad=12.8p as=12.8p pd=33.6u ps=33.6u m=1
X109 xtemp__N2__t6 xtemp__NB__t4 xtemp__NT__t7 xtemp__NT__t13 pfet_03v3 L=4u W=16u nf=1 ad=12.8p as=12.8p pd=33.6u ps=33.6u m=1
X110 xtemp__N2__t5 xtemp__NB__t3 xtemp__NT__t6 xtemp__NT__t12 pfet_03v3 L=4u W=16u nf=1 ad=12.8p as=12.8p pd=33.6u ps=33.6u m=1
X111 xtemp__N1__t7 xtemp__NA__t5 xtemp__NT__t10 xtemp__NT__t16 pfet_03v3 L=4u W=16u nf=1 ad=12.8p as=12.8p pd=33.6u ps=33.6u m=1
X112 xtemp__NT__t3 xtemp__NT__t5 xtemp__NT__t11 xtemp__NT__t17 pfet_03v3 L=4u W=16u nf=1 ad=12.8p as=12.8p pd=33.6u ps=33.6u m=1
X113 xtemp__NT__t0 xtemp__PB__t0 VDD__t36 VDD__t33 pfet_03v3 L=4u W=20u nf=1 ad=16p as=16p pd=41.6u ps=41.6u m=1
X114 VDD__t61 VDD__t59 VDD__t34 VDD__t35 pfet_03v3 L=4u W=4u nf=1 ad=3.2p as=3.2p pd=9.6u ps=9.6u m=1
X115 xtemp__M1D__t0 xtemp__PG__t4 VDD__t52 VDD__t45 pfet_03v3 L=4u W=4u nf=1 ad=3.2p as=3.2p pd=9.6u ps=9.6u m=1
X116 xtemp__NA__t3 xtemp__PCAS__t4 xtemp__M1D__t3 VDD__t84 pfet_03v3 L=1u W=4u nf=1 ad=3.2p as=3.2p pd=9.6u ps=9.6u m=1
X117 xtemp__M2D__t0 xtemp__PG__t5 VDD__t53 VDD__t46 pfet_03v3 L=4u W=4u nf=1 ad=3.2p as=3.2p pd=9.6u ps=9.6u m=1
X118 xtemp__NB__t1 xtemp__PCAS__t6 xtemp__M2D__t2 VDD__t87 pfet_03v3 L=1u W=4u nf=1 ad=3.2p as=3.2p pd=9.6u ps=9.6u m=1
X119 xtemp__M3D__t0 xtemp__PG__t1 VDD__t54 VDD__t47 pfet_03v3 L=4u W=4u nf=1 ad=3.2p as=3.2p pd=9.6u ps=9.6u m=1
X120 PTAT__t2 xtemp__PCAS__t5 xtemp__M3D__t2 VDD__t85 pfet_03v3 L=1u W=4u nf=1 ad=3.2p as=3.2p pd=9.6u ps=9.6u m=1
X121 PTAT__t3 xtemp__PCAS__t8 xtemp__M3D__t3 VDD__t89 pfet_03v3 L=1u W=4u nf=1 ad=3.2p as=3.2p pd=9.6u ps=9.6u m=1
X122 xtemp__M3D__t1 xtemp__PG__t8 VDD__t58 VDD__t51 pfet_03v3 L=4u W=4u nf=1 ad=3.2p as=3.2p pd=9.6u ps=9.6u m=1
X123 xtemp__NB__t2 xtemp__PCAS__t7 xtemp__M2D__t3 VDD__t88 pfet_03v3 L=1u W=4u nf=1 ad=3.2p as=3.2p pd=9.6u ps=9.6u m=1
X124 xtemp__M2D__t1 xtemp__PG__t7 VDD__t57 VDD__t50 pfet_03v3 L=4u W=4u nf=1 ad=3.2p as=3.2p pd=9.6u ps=9.6u m=1
X125 xtemp__NA__t2 xtemp__PCAS__t3 xtemp__M1D__t2 VDD__t83 pfet_03v3 L=1u W=4u nf=1 ad=3.2p as=3.2p pd=9.6u ps=9.6u m=1
X126 xtemp__M1D__t1 xtemp__PG__t6 VDD__t55 VDD__t48 pfet_03v3 L=4u W=4u nf=1 ad=3.2p as=3.2p pd=9.6u ps=9.6u m=1
X127 VDD__t62 VDD__t60 VDD__t56 VDD__t49 pfet_03v3 L=4u W=4u nf=1 ad=3.2p as=3.2p pd=9.6u ps=9.6u m=1
X128 xtemp__PG__t2 xtemp__PB__t1 VDD__t37 VDD__t38 pfet_03v3 L=4u W=10u nf=1 ad=8p as=8p pd=21.6u ps=21.6u m=1
X129 xtemp__PB__t4 xtemp__PB__t2 VDD__t44 VDD__t43 pfet_03v3 L=4u W=10u nf=1 ad=8p as=8p pd=21.6u ps=21.6u m=1
X130 xtemp__PCAS__t1 xtemp__PCAS__t2 VDD__t39 VDD__t40 pfet_03v3 L=8u W=1u nf=1 ad=0.8p as=0.8p pd=3.6u ps=3.6u m=1
X131 xtemp__ENB__t5 RESETn__t7 VDD__t76 VDD__t73 pfet_03v3 L=0.5u W=2u nf=1 ad=1.6p as=1.6p pd=5.6u ps=5.6u m=1
X132 xtemp__ND__t1 xtemp__PB__t3 VDD__t42 VDD__t41 pfet_03v3 L=8u W=1u nf=1 ad=0.8p as=0.8p pd=3.6u ps=3.6u m=1
X133 xtemp__NR__t3 xtemp__PG__t11 VDD__t94 VDD__t90 pfet_03v3 L=4u W=1u nf=1 ad=0.8p as=0.8p pd=3.6u ps=3.6u m=1
X134 xtemp__PG__t9 RESETn__t6 VDD__t80 VDD__t77 pfet_03v3 L=0.5u W=4u nf=1 ad=3.2p as=3.2p pd=9.6u ps=9.6u m=1
X135 xcmp__BIAS_OKB__t4 BIAS_OK__t2 VDD__t31 VDD__t32 pfet_03v3 L=0.5u W=2u nf=1 ad=1.6p as=1p pd=5.6u ps=5u m=1
X136 VSS__t90 VSS__t50 xbias__EC__t6 pnp_10p00x10p00
X137 VSS__t91 VSS__t49 xbias__EC__t5 pnp_10p00x10p00
X138 VSS__t92 VSS__t48 xbias__EC__t4 pnp_10p00x10p00
X139 VSS__t93 VSS__t47 xbias__EC__t3 pnp_10p00x10p00
X140 VSS__t94 VSS__t46 xbias__NA__t2 pnp_10p00x10p00
X141 VSS__t95 VSS__t45 xbias__EC__t2 pnp_10p00x10p00
X142 VSS__t96 VSS__t53 xbias__ER__t1 pnp_10p00x10p00
X143 VSS__t97 VSS__t23 xbias__EC__t0 pnp_10p00x10p00
X144 VSS__t98 VSS__t52 xbias__EC__t8 pnp_10p00x10p00
X145 VSS__t99 VSS__t51 xbias__EC__t7 pnp_10p00x10p00
X146 VSS__t100 VSS__t28 xtemp__NC__t1 pnp_10p00x10p00
X147 VSS__t101 VSS__t29 xtemp__NC__t2 pnp_10p00x10p00
X148 VSS__t102 VSS__t30 xtemp__NC__t3 pnp_10p00x10p00
X149 VSS__t103 VSS__t31 xtemp__NC__t4 pnp_10p00x10p00
X150 VSS__t104 VSS__t36 xtemp__NA__t1 pnp_10p00x10p00
X151 VSS__t105 VSS__t35 xtemp__NC__t8 pnp_10p00x10p00
X152 VSS__t106 VSS__t34 xtemp__NC__t7 pnp_10p00x10p00
X153 VSS__t107 VSS__t33 xtemp__NC__t6 pnp_10p00x10p00
X154 VSS__t108 VSS__t32 xtemp__NC__t5 pnp_10p00x10p00
X155 xpor__NDG__t2 VSS__t26 cap_mim_2f0_m3m4_noshield c_width=11u c_length=11u
X156 xpor__TIM__t1 VSS__t25 cap_mim_2f0_m3m4_noshield c_width=28u c_length=28u
X157 xpor__TIM__t4 VSS__t39 cap_mim_2f0_m3m4_noshield c_width=28u c_length=28u
X158 VDD__t30 xbias__NOKX__t1 cap_mim_2f0_m3m4_noshield c_width=6u c_length=6u
X159 xbias__PG__t4 xbias__NZ__t0 cap_mim_2f0_m3m4_noshield c_width=20u c_length=20u
X160 xpor__TIM__t3 VSS__t38 cap_mim_2f0_m3m4_noshield c_width=28u c_length=28u
X161 xpor__TIM__t2 VSS__t37 cap_mim_2f0_m3m4_noshield c_width=28u c_length=28u
X162 xtemp__PG__t3 xtemp__NZ__t1 cap_mim_2f0_m3m4_noshield c_width=12u c_length=12u
X163 xtemp__NB__t0 xtemp__XR1__1__t0 VSS__t109 ppolyf_u r_width=2u r_length=59.735u
X164 xtemp__NC__t0 xtemp__XR1__1__t1 VSS__t110 ppolyf_u r_width=2u r_length=59.735u
X165 xtemp__NA__t0 xtemp__XRISO__1__t0 VSS__t111 ppolyf_u r_width=2u r_length=55.525u
X166 CTAT__t0 xtemp__XRISO__1__t1 VSS__t112 ppolyf_u r_width=2u r_length=55.525u
X167 xtemp__NZ__t0 xtemp__XRZ__1__t0 VSS__t113 ppolyf_u r_width=2u r_length=100u
X168 xtemp__XRZ__2__t0 xtemp__XRZ__1__t1 VSS__t114 ppolyf_u r_width=2u r_length=100u
X169 xtemp__XRZ__2__t1 xtemp__XRZ__3__t0 VSS__t115 ppolyf_u r_width=2u r_length=100u
X170 xtemp__XRZ__4__t0 xtemp__XRZ__3__t1 VSS__t116 ppolyf_u r_width=2u r_length=100u
X171 xtemp__XRZ__4__t1 xtemp__XRZ__5__t0 VSS__t117 ppolyf_u r_width=2u r_length=100u
X172 xtemp__XRZ__6__t1 xtemp__XRZ__5__t1 VSS__t118 ppolyf_u r_width=2u r_length=100u
X173 xtemp__XRZ__6__t0 xtemp__XRZ__7__t1 VSS__t119 ppolyf_u r_width=2u r_length=100u
X174 xtemp__XRZ__8__t1 xtemp__XRZ__7__t0 VSS__t120 ppolyf_u r_width=2u r_length=100u
X175 xtemp__XRZ__8__t0 xtemp__XRZ__9__t1 VSS__t121 ppolyf_u r_width=2u r_length=100u
X176 xtemp__N2__t0 xtemp__XRZ__9__t0 VSS__t122 ppolyf_u r_width=2u r_length=100u
X177 PTAT__t0 xtemp__XR2F__1__t0 VSS__t123 ppolyf_u r_width=2u r_length=110.525u
X178 xtemp__XR2F__2__t1 xtemp__XR2F__1__t1 VSS__t124 ppolyf_u r_width=2u r_length=110.525u
X179 xtemp__XR2F__2__t0 xtemp__XR2F__3__t0 VSS__t125 ppolyf_u r_width=2u r_length=110.525u
X180 xtemp__XR2F__4__t1 xtemp__XR2F__3__t1 VSS__t126 ppolyf_u r_width=2u r_length=110.525u
X181 xtemp__XR2F__4__t0 xtemp__XR2F__5__t0 VSS__t127 ppolyf_u r_width=2u r_length=110.525u
X182 xtemp__XR2F__6__t1 xtemp__XR2F__5__t1 VSS__t128 ppolyf_u r_width=2u r_length=110.525u
X183 xtemp__XR2F__6__t0 xtemp__XR2F__7__t1 VSS__t129 ppolyf_u r_width=2u r_length=110.525u
X184 xtemp__XR2F__8__t1 xtemp__XR2F__7__t0 VSS__t130 ppolyf_u r_width=2u r_length=110.525u
X185 xtemp__XR2F__8__t0 xtemp__XR2F__9__t1 VSS__t131 ppolyf_u r_width=2u r_length=110.525u
X186 xtemp__XR2F__10__t1 xtemp__XR2F__9__t0 VSS__t132 ppolyf_u r_width=2u r_length=110.525u
X187 xtemp__XR2F__10__t0 xtemp__XR2F__11__t1 VSS__t133 ppolyf_u r_width=2u r_length=110.525u
X188 xtemp__XR2F__12__t1 xtemp__XR2F__11__t0 VSS__t134 ppolyf_u r_width=2u r_length=110.525u
X189 xtemp__XR2F__12__t0 xtemp__XR2F__13__t1 VSS__t135 ppolyf_u r_width=2u r_length=110.525u
X190 xtemp__XR2F__14__t0 xtemp__XR2F__13__t0 VSS__t136 ppolyf_u r_width=2u r_length=110.525u
X191 xtemp__XR2F__14__t1 xtemp__XR2F__15__t1 VSS__t137 ppolyf_u r_width=2u r_length=110.525u
X192 xtemp__XR2F__16__t1 xtemp__XR2F__15__t0 VSS__t138 ppolyf_u r_width=2u r_length=110.525u
X193 xtemp__XR2F__16__t0 xtemp__XR2F__17__t1 VSS__t139 ppolyf_u r_width=2u r_length=110.525u
X194 xtemp__XR2F__18__t1 xtemp__XR2F__17__t0 VSS__t140 ppolyf_u r_width=2u r_length=110.525u
X195 xtemp__XR2F__18__t0 xtemp__XR2F__19__t1 VSS__t141 ppolyf_u r_width=2u r_length=110.525u
X196 xtemp__XR2F__20__t1 xtemp__XR2F__19__t0 VSS__t142 ppolyf_u r_width=2u r_length=110.525u
X197 xtemp__XR2F__20__t0 xtemp__XR2F__21__t1 VSS__t143 ppolyf_u r_width=2u r_length=110.525u
X198 xtemp__XR2F__22__t1 xtemp__XR2F__21__t0 VSS__t144 ppolyf_u r_width=2u r_length=110.525u
X199 xtemp__XR2F__22__t0 xtemp__XR2F__23__t1 VSS__t145 ppolyf_u r_width=2u r_length=110.525u
X200 xtemp__T5__t2 xtemp__XR2F__23__t0 VSS__t146 ppolyf_u r_width=2u r_length=110.525u
X201 xtemp__T5__t1 xtemp__XR2T5__1__t0 VSS__t147 ppolyf_u r_width=2u r_length=114.855u
X202 xtemp__T4__t2 xtemp__XR2T5__1__t1 VSS__t148 ppolyf_u r_width=2u r_length=114.855u
X203 xtemp__T4__t1 xtemp__XR2T4__1__t0 VSS__t149 ppolyf_u r_width=2u r_length=57.345u
X204 xtemp__T3__t1 xtemp__XR2T4__1__t1 VSS__t150 ppolyf_u r_width=2u r_length=57.345u
X205 xtemp__T3__t0 xtemp__XR2T3__1__t0 VSS__t151 ppolyf_u r_width=2u r_length=28.59u
X206 xtemp__T2__t1 xtemp__XR2T3__1__t1 VSS__t152 ppolyf_u r_width=2u r_length=28.59u
X207 xtemp__T2__t0 xtemp__XR2T2__1__t0 VSS__t153 ppolyf_u r_width=2u r_length=14.21u
X208 xtemp__T1__t1 xtemp__XR2T2__1__t1 VSS__t154 ppolyf_u r_width=2u r_length=14.21u
X209 xtemp__T1__t0 xtemp__XR2T1__1__t0 VSS__t155 ppolyf_u r_width=2u r_length=7.015u
X210 xtemp__T0__t1 xtemp__XR2T1__1__t1 VSS__t156 ppolyf_u r_width=2u r_length=7.015u
X211 xtemp__T0__t0 xtemp__XR2T0__1__t0 VSS__t157 ppolyf_u r_width=2u r_length=3.425u
X212 VSS__t27 xtemp__XR2T0__1__t1 VSS__t158 ppolyf_u r_width=2u r_length=3.425u
X213 xcmp__SNSB__t0 xcmp__SNS__t1 VSS__t159 ppolyf_u_3k r_width=2u r_length=6769.23u
X214 VSS__t0 xcmp__SNSB__t2 VSS__t160 ppolyf_u_3k r_width=2u r_length=775u
X215 xcmp__SNS__t0 VDD__t0 VSS__t161 ppolyf_u_3k r_width=2u r_length=7897.44u
X216 VREF__t0 xbias__XR2__1__t0 VSS__t162 ppolyf_u_3k r_width=2u r_length=256.5u
X217 xbias__XR2__2__t1 xbias__XR2__1__t1 VSS__t163 ppolyf_u_3k r_width=2u r_length=256.5u
X218 xbias__XR2__2__t0 xbias__XR2__3__t1 VSS__t170 ppolyf_u_3k r_width=2u r_length=256.5u
X219 xbias__XR2__4__t0 xbias__XR2__3__t0 VSS__t164 ppolyf_u_3k r_width=2u r_length=256.5u
X220 xbias__XR2__4__t1 xbias__XR2__5__t0 VSS__t171 ppolyf_u_3k r_width=2u r_length=256.5u
X221 xbias__XR2__6__t0 xbias__XR2__5__t1 VSS__t165 ppolyf_u_3k r_width=2u r_length=256.5u
X222 xbias__XR2__6__t1 xbias__XR2__7__t0 VSS__t172 ppolyf_u_3k r_width=2u r_length=256.5u
X223 xbias__XR2__8__t0 xbias__XR2__7__t1 VSS__t166 ppolyf_u_3k r_width=2u r_length=256.5u
X224 xbias__XR2__8__t1 xbias__XR2__9__t0 VSS__t173 ppolyf_u_3k r_width=2u r_length=256.5u
X225 xbias__XR2__10__t0 xbias__XR2__9__t1 VSS__t167 ppolyf_u_3k r_width=2u r_length=256.5u
X226 xbias__XR2__10__t1 xbias__XR2__11__t0 VSS__t174 ppolyf_u_3k r_width=2u r_length=256.5u
X227 xbias__XR2__12__t0 xbias__XR2__11__t1 VSS__t168 ppolyf_u_3k r_width=2u r_length=256.5u
X228 xbias__XR2__12__t1 xbias__XR2__13__t0 VSS__t175 ppolyf_u_3k r_width=2u r_length=256.5u
X229 xbias__XR2__14__t0 xbias__XR2__13__t1 VSS__t169 ppolyf_u_3k r_width=2u r_length=256.5u
X230 xbias__XR2__14__t1 xbias__XR2__15__t0 VSS__t176 ppolyf_u_3k r_width=2u r_length=256.5u
X231 xbias__ER__t0 xbias__XR2__15__t1 VSS__t177 ppolyf_u_3k r_width=2u r_length=256.5u
X232 xbias__NZ__t1 xbias__XRZ__1__t0 VSS__t178 ppolyf_u_3k r_width=2u r_length=254u
X233 xbias__XRZ__2__t1 xbias__XRZ__1__t1 VSS__t179 ppolyf_u_3k r_width=2u r_length=254u
X234 xbias__XRZ__2__t0 xbias__XRZ__3__t1 VSS__t180 ppolyf_u_3k r_width=2u r_length=254u
X235 xbias__N2__t2 xbias__XRZ__3__t0 VSS__t181 ppolyf_u_3k r_width=2u r_length=254u
X236 xbias__NB__t0 xbias__XR1__1__t1 VSS__t182 ppolyf_u_3k r_width=2u r_length=175u
X237 xbias__EC__t1 xbias__XR1__1__t0 VSS__t183 ppolyf_u_3k r_width=2u r_length=175u
X238 xbias__NBTOP__t0 xbias__XRT__1__t1 VSS__t184 ppolyf_u_3k r_width=2u r_length=8.75u
X239 xbias__NB__t1 xbias__XRT__1__t0 VSS__t185 ppolyf_u_3k r_width=2u r_length=8.75u

R_100_t0 xtemp__XR2F__4__t0 xtemp__XR2F__4 25.28745
R_100_t1 xtemp__XR2F__4__t1 xtemp__XR2F__4 25.28745
C_100 xtemp__XR2F__4 VSS 1.599507e-15
R_101_t0 xtemp__XR2F__6__t0 xtemp__XR2F__6 25.28745
R_101_t1 xtemp__XR2F__6__t1 xtemp__XR2F__6 25.28745
C_101 xtemp__XR2F__6 VSS 1.599507e-15
R_102_t0 xtemp__XR2F__8__t0 xtemp__XR2F__8 25.28745
R_102_t1 xtemp__XR2F__8__t1 xtemp__XR2F__8 25.28745
C_102 xtemp__XR2F__8 VSS 1.599507e-15
R_103_t0 xtemp__XR2F__10__t0 xtemp__XR2F__10 25.28745
R_103_t1 xtemp__XR2F__10__t1 xtemp__XR2F__10 25.28745
C_103 xtemp__XR2F__10 VSS 1.599507e-15
R_104_t0 xtemp__XR2F__12__t0 xtemp__XR2F__12 25.28745
R_104_t1 xtemp__XR2F__12__t1 xtemp__XR2F__12 25.28745
C_104 xtemp__XR2F__12 VSS 1.599507e-15
R_105_t0 xtemp__XR2F__14__t0 xtemp__XR2F__14 25.28745
R_105_t1 xtemp__XR2F__14__t1 xtemp__XR2F__14 25.28745
C_105 xtemp__XR2F__14 VSS 1.599507e-15
R_106_t0 xtemp__XR2F__16__t0 xtemp__XR2F__16 25.28745
R_106_t1 xtemp__XR2F__16__t1 xtemp__XR2F__16 25.28745
C_106 xtemp__XR2F__16 VSS 1.599507e-15
R_107_t0 xtemp__XR2F__18__t0 xtemp__XR2F__18 25.28745
R_107_t1 xtemp__XR2F__18__t1 xtemp__XR2F__18 25.28745
C_107 xtemp__XR2F__18 VSS 1.599507e-15
R_108_t0 xtemp__XR2F__20__t0 xtemp__XR2F__20 25.28745
R_108_t1 xtemp__XR2F__20__t1 xtemp__XR2F__20 25.28745
C_108 xtemp__XR2F__20 VSS 1.599507e-15
R_109_t0 xtemp__XR2F__22__t0 xtemp__XR2F__22 25.28745
R_109_t1 xtemp__XR2F__22__t1 xtemp__XR2F__22 25.28745
C_109 xtemp__XR2F__22 VSS 1.599507e-15
R_11_t0 xbias__NT__t0 xbias__NT 627.59414468
R_11_t1 xbias__NT__t1 xbias__NT 1882.86781906
R_11_t2 xbias__NT__t2 xbias__NT 2174.12383626
C_11 xbias__NT VSS 4.9951788e-14
R_115_t0 xtemp__XR2T0__1__t0 xtemp__XR2T0__1 25.28745
R_115_t1 xtemp__XR2T0__1__t1 xtemp__XR2T0__1 25.28745
C_115 xtemp__XR2T0__1 VSS 1.599507e-15
R_116_t0 xtemp__XR2T1__1__t0 xtemp__XR2T1__1 25.28745
R_116_t1 xtemp__XR2T1__1__t1 xtemp__XR2T1__1 25.28745
C_116 xtemp__XR2T1__1 VSS 1.599507e-15
R_12_t0 xbias__N1__t0 xbias__N1 2483.75464397
R_12_t1 xbias__N1__t1 xbias__N1 686.286100229
R_12_t2 xbias__N1__t2 xbias__N1 1111.53145557
R_12_t3 xbias__N1__t3 xbias__N1 686.286100229
C_12 xbias__N1 VSS 5.978126e-14
R_120_t0 xtemp__XR2T2__1__t0 xtemp__XR2T2__1 25.28745
R_120_t1 xtemp__XR2T2__1__t1 xtemp__XR2T2__1 25.28745
C_120 xtemp__XR2T2__1 VSS 1.599507e-15
R_124_t0 xtemp__XR2T3__1__t0 xtemp__XR2T3__1 25.28745
R_124_t1 xtemp__XR2T3__1__t1 xtemp__XR2T3__1 25.28745
C_124 xtemp__XR2T3__1 VSS 1.599507e-15
R_13_t0 xbias__N2__t0 xbias__N2 979.748226084
R_13_t1 xbias__N2__t1 xbias__N2 827.153205074
R_13_t2 xbias__N2__t2 xbias__N2 3874.61260019
R_13_t3 xbias__N2__t3 xbias__N2 2173.53656866
C_13 xbias__N2 VSS 8.4773094e-14
R_132_t0 xtemp__XRISO__1__t0 xtemp__XRISO__1 25.28745
R_132_t1 xtemp__XRISO__1__t1 xtemp__XRISO__1 25.28745
C_132 xtemp__XRISO__1 VSS 1.599507e-15
R_133_t0 xtemp__XR2T4__1__t0 xtemp__XR2T4__1 25.28745
R_133_t1 xtemp__XR2T4__1__t1 xtemp__XR2T4__1 25.28745
C_133 xtemp__XR2T4__1 VSS 1.599507e-15
R_134_t0 xtemp__XR1__1__t0 xtemp__XR1__1 25.28745
R_134_t1 xtemp__XR1__1__t1 xtemp__XR1__1 25.28745
C_134 xtemp__XR1__1 VSS 1.599507e-15
R_135_t0 xtemp__XRZ__1__t0 xtemp__XRZ__1 25.28745
R_135_t1 xtemp__XRZ__1__t1 xtemp__XRZ__1 25.28745
C_135 xtemp__XRZ__1 VSS 1.599507e-15
R_136_t0 xtemp__XRZ__3__t0 xtemp__XRZ__3 25.28745
R_136_t1 xtemp__XRZ__3__t1 xtemp__XRZ__3 25.28745
C_136 xtemp__XRZ__3 VSS 1.599507e-15
R_137_t0 xtemp__XRZ__5__t0 xtemp__XRZ__5 25.28745
R_137_t1 xtemp__XRZ__5__t1 xtemp__XRZ__5 25.28745
C_137 xtemp__XRZ__5 VSS 1.599507e-15
R_138_t0 xtemp__XRZ__7__t0 xtemp__XRZ__7 25.28745
R_138_t1 xtemp__XRZ__7__t1 xtemp__XRZ__7 25.28745
C_138 xtemp__XRZ__7 VSS 1.599507e-15
R_139_t0 xtemp__XRZ__9__t0 xtemp__XRZ__9 25.28745
R_139_t1 xtemp__XRZ__9__t1 xtemp__XRZ__9 25.28745
C_139 xtemp__XRZ__9 VSS 1.599507e-15
R_14_t0 xbias__TOK__t0 xbias__TOK 2208.25155211
R_14_t1 xbias__TOK__t1 xbias__TOK 368.025235243
R_14_t2 xbias__TOK__t2 xbias__TOK 2114.24861265
C_14 xbias__TOK VSS 5.2350545e-14
R_140_t0 xtemp__XR2F__1__t0 xtemp__XR2F__1 25.28745
R_140_t1 xtemp__XR2F__1__t1 xtemp__XR2F__1 25.28745
C_140 xtemp__XR2F__1 VSS 1.599507e-15
R_141_t0 xtemp__XR2F__3__t0 xtemp__XR2F__3 25.28745
R_141_t1 xtemp__XR2F__3__t1 xtemp__XR2F__3 25.28745
C_141 xtemp__XR2F__3 VSS 1.599507e-15
R_142_t0 xtemp__XR2F__5__t0 xtemp__XR2F__5 25.28745
R_142_t1 xtemp__XR2F__5__t1 xtemp__XR2F__5 25.28745
C_142 xtemp__XR2F__5 VSS 1.599507e-15
R_143_t0 xtemp__XR2F__7__t0 xtemp__XR2F__7 25.28745
R_143_t1 xtemp__XR2F__7__t1 xtemp__XR2F__7 25.28745
C_143 xtemp__XR2F__7 VSS 1.599507e-15
R_144_t0 xtemp__XR2F__9__t0 xtemp__XR2F__9 25.28745
R_144_t1 xtemp__XR2F__9__t1 xtemp__XR2F__9 25.28745
C_144 xtemp__XR2F__9 VSS 1.599507e-15
R_145_t0 xtemp__XR2F__11__t0 xtemp__XR2F__11 25.28745
R_145_t1 xtemp__XR2F__11__t1 xtemp__XR2F__11 25.28745
C_145 xtemp__XR2F__11 VSS 1.599507e-15
R_146_t0 xtemp__XR2F__13__t0 xtemp__XR2F__13 25.28745
R_146_t1 xtemp__XR2F__13__t1 xtemp__XR2F__13 25.28745
C_146 xtemp__XR2F__13 VSS 1.599507e-15
R_147_t0 xtemp__XR2F__15__t0 xtemp__XR2F__15 25.28745
R_147_t1 xtemp__XR2F__15__t1 xtemp__XR2F__15 25.28745
C_147 xtemp__XR2F__15 VSS 1.599507e-15
R_148_t0 xtemp__XR2F__17__t0 xtemp__XR2F__17 25.28745
R_148_t1 xtemp__XR2F__17__t1 xtemp__XR2F__17 25.28745
C_148 xtemp__XR2F__17 VSS 1.599507e-15
R_149_t0 xtemp__XR2F__19__t0 xtemp__XR2F__19 25.28745
R_149_t1 xtemp__XR2F__19__t1 xtemp__XR2F__19 25.28745
C_149 xtemp__XR2F__19 VSS 1.599507e-15
R_15_t0 xbias__NOKO__t0 xbias__NOKO 798.735608557
R_15_t1 xbias__NOKO__t1 xbias__NOKO 900.604258303
R_15_t2 xbias__NOKO__t2 xbias__NOKO 696.871607469
R_15_t3 xbias__NOKO__t3 xbias__NOKO 2396.20682567
C_15 xbias__NOKO VSS 5.9161863e-14
R_150_t0 xtemp__XR2F__21__t0 xtemp__XR2F__21 25.28745
R_150_t1 xtemp__XR2F__21__t1 xtemp__XR2F__21 25.28745
C_150 xtemp__XR2F__21 VSS 1.599507e-15
R_151_t0 xtemp__XR2F__23__t0 xtemp__XR2F__23 25.28745
R_151_t1 xtemp__XR2F__23__t1 xtemp__XR2F__23 25.28745
C_151 xtemp__XR2F__23 VSS 1.599507e-15
R_152_t0 xtemp__XR2T5__1__t0 xtemp__XR2T5__1 25.28745
R_152_t1 xtemp__XR2T5__1__t1 xtemp__XR2T5__1 25.28745
C_152 xtemp__XR2T5__1 VSS 1.599507e-15
R_16_t0 xbias__NOKL__t0 xbias__NOKL 764.207687226
R_16_t1 xbias__NOKL__t1 xbias__NOKL 913.585012659
R_16_t2 xbias__NOKL__t2 xbias__NOKL 764.207687226
R_16_t3 xbias__NOKL__t3 xbias__NOKL 2441.99661289
C_16 xbias__NOKL VSS 6.0794305e-14
R_17_t0 xbias__NKG__t0 xbias__NKG 486.627728791
R_17_t1 xbias__NKG__t1 xbias__NKG 276.439255717
R_17_t2 xbias__NKG__t2 xbias__NKG 2120.36414661
R_17_t3 xbias__NKG__t3 xbias__NKG 1964.61916888
C_17 xbias__NKG VSS 5.7785044e-14
R_18_t0 xbias__NB__t0 xbias__NB 1961.46264717
R_18_t1 xbias__NB__t1 xbias__NB 1980.02899168
R_18_t2 xbias__NB__t2 xbias__NB 3725.54776115
C_18 xbias__NB VSS 7.6112691e-14
R_19_t0 xcmp__VDDA__t0 xcmp__VDDA 631.9122
R_19_t1 xcmp__VDDA__t1 xcmp__VDDA 616.937977251
R_19_t2 xcmp__VDDA__t2 xcmp__VDDA 14.9742227488
C_19 xcmp__VDDA VSS 1.4679011e-14
R_20_t0 xcmp__NA__t0 xcmp__NA 288.034386996
R_20_t1 xcmp__NA__t1 xcmp__NA 288.034386996
R_20_t2 xcmp__NA__t2 xcmp__NA 116.445087634
R_20_t3 xcmp__NA__t3 xcmp__NA 692.332138375
C_20 xcmp__NA VSS 1.5868526e-14
R_21_t0 xcmp__CMPO__t0 xcmp__CMPO 261.418858782
R_21_t1 xcmp__CMPO__t1 xcmp__CMPO 366.105615344
R_21_t2 xcmp__CMPO__t2 xcmp__CMPO 340.793554757
R_21_t3 xcmp__CMPO__t3 xcmp__CMPO 324.899769804
R_21_t4 xcmp__CMPO__t4 xcmp__CMPO 88.9071013133
C_21 xcmp__CMPO VSS 1.7766709e-14
R_23_t0 xcmp__N1__t0 xcmp__N1 377.193158999
R_23_t1 xcmp__N1__t1 xcmp__N1 175.868361694
R_23_t2 xcmp__N1__t2 xcmp__N1 253.833596266
R_23_t3 xcmp__N1__t3 xcmp__N1 292.041043747
R_23_t4 xcmp__N1__t4 xcmp__N1 338.946339293
C_23 xcmp__N1 VSS 1.7866109e-14
R_24_t0 xcmp__TN__t0 xcmp__TN 630.394143252
R_24_t1 xcmp__TN__t1 xcmp__TN 486.762381087
R_24_t2 xcmp__TN__t2 xcmp__TN 143.96957566
C_24 xcmp__TN VSS 1.3588667e-14
R_25_t0 xcmp__SNS__t0 xcmp__SNS 122.891188735
R_25_t1 xcmp__SNS__t1 xcmp__SNS 684.260298411
R_25_t2 xcmp__SNS__t2 xcmp__SNS 686.317212854
C_25 xcmp__SNS VSS 5.2676745e-14
R_26_t0 xcmp__NBG__t0 xcmp__NBG 715.139441326
R_26_t1 xcmp__NBG__t1 xcmp__NBG 44.0457601943
R_26_t2 xcmp__NBG__t2 xcmp__NBG 499.88258088
R_26_t3 xcmp__NBG__t3 xcmp__NBG 257.887617601
C_26 xcmp__NBG VSS 2.1326008e-14
R_27_t0 xcmp__SNSB__t0 xcmp__SNSB 212.505970377
R_27_t1 xcmp__SNSB__t1 xcmp__SNSB 688.024299088
R_27_t2 xcmp__SNSB__t2 xcmp__SNSB 513.046030534
C_27 xcmp__SNSB VSS 4.4264354e-14
R_28_t0 xpor__PDN__t0 xpor__PDN 2192.18513758
R_28_t1 xpor__PDN__t1 xpor__PDN 119.940253161
R_28_t2 xpor__PDN__t2 xpor__PDN 119.940253161
R_28_t3 xpor__PDN__t3 xpor__PDN 470.418947224
R_28_t4 xpor__PDN__t4 xpor__PDN 753.814003433
R_28_t5 xpor__PDN__t5 xpor__PDN 1044.80236751
R_28_t6 xpor__PDN__t6 xpor__PDN 171.383237922
C_28 xpor__PDN VSS 5.6528747e-14
R_29_t0 xpor__NDL__t0 xpor__NDL 878.61286536
R_29_t1 xpor__NDL__t1 xpor__NDL 878.61286536
R_29_t2 xpor__NDL__t2 xpor__NDL 479.294941313
R_29_t3 xpor__NDL__t3 xpor__NDL 418.160636306
R_29_t4 xpor__NDL__t4 xpor__NDL 1807.81299166
C_29 xpor__NDL VSS 4.7374149e-14
R_30_t0 xpor__NDGN__t0 xpor__NDGN 1968.54035
R_30_t1 xpor__NDGN__t1 xpor__NDGN 1968.54035
C_30 xpor__NDGN VSS 3.4262384e-14
R_31_t0 xpor__PGDG__t0 xpor__PGDG 818.584937735
R_31_t1 xpor__PGDG__t1 xpor__PGDG 602.446318769
R_31_t2 xpor__PGDG__t2 xpor__PGDG 405.068343117
R_31_t3 xpor__PGDG__t3 xpor__PGDG 870.985079265
R_31_t4 xpor__PGDG__t4 xpor__PGDG 837.510194981
R_31_t5 xpor__PGDG__t5 xpor__PGDG 654.828626133
C_31 xpor__PGDG VSS 4.2322747e-14
R_32_t0 xpor__PGDGB__t0 xpor__PGDGB 1055.41000903
R_32_t1 xpor__PGDGB__t1 xpor__PGDGB 1048.31915217
R_32_t2 xpor__PGDGB__t2 xpor__PGDGB 978.029067333
R_32_t3 xpor__PGDGB__t3 xpor__PGDGB 985.115471459
C_32 xpor__PGDGB VSS 3.8921287e-14
R_33_t0 xpor__ND1__t0 xpor__ND1 851.440640246
R_33_t1 xpor__ND1__t1 xpor__ND1 2004.66951985
R_33_t2 xpor__ND1__t2 xpor__ND1 526.661303231
R_33_t3 xpor__ND1__t3 xpor__ND1 626.580236676
C_33 xpor__ND1 VSS 3.9492693e-14
R_34_t0 xpor__NNAND__t0 xpor__NNAND 1969.9799
R_34_t1 xpor__NNAND__t1 xpor__NNAND 1969.9799
C_34 xpor__NNAND VSS 3.5401418e-14
R_35_t0 xpor__NDGP__t0 xpor__NDGP 1968.36045
R_35_t1 xpor__NDGP__t1 xpor__NDGP 1968.36045
C_35 xpor__NDGP VSS 3.4117005e-14
R_36_t0 xpor__NTS__t0 xpor__NTS 1969.2657
R_36_t1 xpor__NTS__t1 xpor__NTS 1969.2657
C_36 xpor__NTS VSS 3.4836444e-14
R_37_t0 xpor__RSTB__t0 xpor__RSTB 577.101205748
R_37_t1 xpor__RSTB__t1 xpor__RSTB 386.186232677
R_37_t2 xpor__RSTB__t2 xpor__RSTB 754.19830579
R_37_t3 xpor__RSTB__t3 xpor__RSTB 2034.86326663
R_37_t4 xpor__RSTB__t4 xpor__RSTB 198.604997756
R_37_t5 xpor__RSTB__t5 xpor__RSTB 125.223191397
C_37 xpor__RSTB VSS 4.4183369e-14
R_39_t0 xbias__NKM__t0 xbias__NKM 2437.59006439
R_39_t1 xbias__NKM__t1 xbias__NKM 762.895630051
R_39_t2 xbias__NKM__t2 xbias__NKM 913.50607551
R_39_t3 xbias__NKM__t3 xbias__NKM 762.895630051
C_39 xbias__NKM VSS 5.7923066e-14
R_40_t0 xbias__NOKX__t0 xbias__NOKX 648.721578834
R_40_t1 xbias__NOKX__t1 xbias__NOKX 1279.90073207
R_40_t2 xbias__NOKX__t2 xbias__NOKX 597.005875788
R_40_t3 xbias__NOKX__t3 xbias__NOKX 1204.49559346
R_40_t4 xbias__NOKX__t4 xbias__NOKX 1128.46241984
C_40 xbias__NOKX VSS 6.414389e-14
R_41_t0 xbias__KS1__t0 xbias__KS1 2409.42555
R_41_t1 xbias__KS1__t1 xbias__KS1 1204.712775
R_41_t2 xbias__KS1__t2 xbias__KS1 1204.712775
C_41 xbias__KS1 VSS 5.4330567e-14
R_42_t0 xbias__KS2__t0 xbias__KS2 2409.69555
R_42_t1 xbias__KS2__t1 xbias__KS2 1204.847775
R_42_t2 xbias__KS2__t2 xbias__KS2 1204.847775
C_42 xbias__KS2 VSS 5.4548635e-14
R_43_t0 xbias__KS3__t0 xbias__KS3 2409.9655
R_43_t1 xbias__KS3__t1 xbias__KS3 1204.98275
R_43_t2 xbias__KS3__t2 xbias__KS3 1204.98275
C_43 xbias__KS3 VSS 5.4766704e-14
R_44_t0 xbias__KS4__t0 xbias__KS4 2410.2355
R_44_t1 xbias__KS4__t1 xbias__KS4 1205.11775
R_44_t2 xbias__KS4__t2 xbias__KS4 1205.11775
C_44 xbias__KS4 VSS 5.4984773e-14
R_45_t0 xbias__NZ__t0 xbias__NZ 1400.6452
R_45_t1 xbias__NZ__t1 xbias__NZ 1400.6452
C_45 xbias__NZ VSS 3.1064128e-14
R_46_t0 xbias__EC__t0 xbias__EC 275.91173659
R_46_t1 xbias__EC__t1 xbias__EC 1152.10022722
R_46_t2 xbias__EC__t2 xbias__EC 72.3260567335
R_46_t3 xbias__EC__t3 xbias__EC 275.91173659
R_46_t4 xbias__EC__t4 xbias__EC 212.391588062
R_46_t5 xbias__EC__t5 xbias__EC 246.208725544
R_46_t6 xbias__EC__t6 xbias__EC 340.597144123
R_46_t7 xbias__EC__t7 xbias__EC 72.3260567335
R_46_t8 xbias__EC__t8 xbias__EC 144.012528403
C_46 xbias__EC VSS 7.4190842e-14
R_47_t0 xpor__NDG__t0 xpor__NDG 954.603905263
R_47_t1 xpor__NDG__t1 xpor__NDG 1014.07506597
R_47_t2 xpor__NDG__t2 xpor__NDG 740.648776922
R_47_t3 xpor__NDG__t3 xpor__NDG 719.797860447
R_47_t4 xpor__NDG__t4 xpor__NDG 671.322091399
C_47 xpor__NDG VSS 5.2682376e-14
R_48_t0 xpor__TIM__t0 xpor__TIM 921.604176272
R_48_t1 xpor__TIM__t1 xpor__TIM 550.192925008
R_48_t2 xpor__TIM__t2 xpor__TIM 450.44845788
R_48_t3 xpor__TIM__t3 xpor__TIM 646.825671411
R_48_t4 xpor__TIM__t4 xpor__TIM 295.351686536
R_48_t5 xpor__TIM__t5 xpor__TIM 892.679198138
R_48_t6 xpor__TIM__t6 xpor__TIM 305.553184754
C_48 xpor__TIM VSS 8.4701074e-14
R_49_t0 xpor__TRIP__t0 xpor__TRIP 694.201632009
R_49_t1 xpor__TRIP__t1 xpor__TRIP 1101.25331834
R_49_t2 xpor__TRIP__t2 xpor__TRIP 928.634222318
R_49_t3 xpor__TRIP__t3 xpor__TRIP 1336.10142733
C_49 xpor__TRIP VSS 3.9432796e-14
R_50_t0 xbias__XR2__2__t0 xbias__XR2__2 9.125
R_50_t1 xbias__XR2__2__t1 xbias__XR2__2 9.125
C_50 xbias__XR2__2 VSS 1.8067e-15
R_51_t0 xbias__XR2__4__t0 xbias__XR2__4 9.125
R_51_t1 xbias__XR2__4__t1 xbias__XR2__4 9.125
C_51 xbias__XR2__4 VSS 1.8067e-15
R_52_t0 xbias__XR2__6__t0 xbias__XR2__6 9.125
R_52_t1 xbias__XR2__6__t1 xbias__XR2__6 9.125
C_52 xbias__XR2__6 VSS 1.8067e-15
R_53_t0 xbias__XR2__8__t0 xbias__XR2__8 9.125
R_53_t1 xbias__XR2__8__t1 xbias__XR2__8 9.125
C_53 xbias__XR2__8 VSS 1.8067e-15
R_54_t0 xbias__XR2__10__t0 xbias__XR2__10 9.125
R_54_t1 xbias__XR2__10__t1 xbias__XR2__10 9.125
C_54 xbias__XR2__10 VSS 1.8067e-15
R_55_t0 xbias__XR2__12__t0 xbias__XR2__12 9.125
R_55_t1 xbias__XR2__12__t1 xbias__XR2__12 9.125
C_55 xbias__XR2__12 VSS 1.8067e-15
R_56_t0 xbias__XR2__14__t0 xbias__XR2__14 9.125
R_56_t1 xbias__XR2__14__t1 xbias__XR2__14 9.125
C_56 xbias__XR2__14 VSS 1.8067e-15
R_57_t0 xbias__XRZ__2__t0 xbias__XRZ__2 9.125
R_57_t1 xbias__XRZ__2__t1 xbias__XRZ__2 9.125
C_57 xbias__XRZ__2 VSS 1.8067e-15
R_58_t0 xbias__XRT__1__t0 xbias__XRT__1 9.125
R_58_t1 xbias__XRT__1__t1 xbias__XRT__1 9.125
C_58 xbias__XRT__1 VSS 1.8067e-15
R_59_t0 xbias__NA__t0 xbias__NA 2219.38475185
R_59_t1 xbias__NA__t1 xbias__NA 1234.10052238
R_59_t2 xbias__NA__t2 xbias__NA 3997.24029431
R_59_t3 xbias__NA__t3 xbias__NA 557.864231464
C_59 xbias__NA VSS 8.7584412e-14
R_6_t0 xbias__PG__t0 xbias__PG 636.433597654
R_6_t1 xbias__PG__t1 xbias__PG 503.959749741
R_6_t2 xbias__PG__t2 xbias__PG 371.362761404
R_6_t3 xbias__PG__t3 xbias__PG 883.803713976
R_6_t4 xbias__PG__t4 xbias__PG 1322.79824296
R_6_t5 xbias__PG__t5 xbias__PG 238.945693911
R_6_t6 xbias__PG__t6 xbias__PG 591.351383441
R_6_t7 xbias__PG__t7 xbias__PG 546.299356917
C_6 xbias__PG VSS 7.8120649e-14
R_60_t0 xbias__ER__t0 xbias__ER 1393.837
R_60_t1 xbias__ER__t1 xbias__ER 1393.837
C_60 xbias__ER VSS 3.3170077e-14
R_61_t0 xbias__XRZ__1__t0 xbias__XRZ__1 9.125
R_61_t1 xbias__XRZ__1__t1 xbias__XRZ__1 9.125
C_61 xbias__XRZ__1 VSS 1.8067e-15
R_62_t0 xbias__XRZ__3__t0 xbias__XRZ__3 9.125
R_62_t1 xbias__XRZ__3__t1 xbias__XRZ__3 9.125
C_62 xbias__XRZ__3 VSS 1.8067e-15
R_63_t0 xbias__XR1__1__t0 xbias__XR1__1 9.125
R_63_t1 xbias__XR1__1__t1 xbias__XR1__1 9.125
C_63 xbias__XR1__1 VSS 1.8067e-15
R_64_t0 xbias__XR2__15__t0 xbias__XR2__15 9.125
R_64_t1 xbias__XR2__15__t1 xbias__XR2__15 9.125
C_64 xbias__XR2__15 VSS 1.8067e-15
R_65_t0 xbias__XR2__13__t0 xbias__XR2__13 9.125
R_65_t1 xbias__XR2__13__t1 xbias__XR2__13 9.125
C_65 xbias__XR2__13 VSS 1.8067e-15
R_66_t0 xbias__XR2__11__t0 xbias__XR2__11 9.125
R_66_t1 xbias__XR2__11__t1 xbias__XR2__11 9.125
C_66 xbias__XR2__11 VSS 1.8067e-15
R_67_t0 xbias__XR2__9__t0 xbias__XR2__9 9.125
R_67_t1 xbias__XR2__9__t1 xbias__XR2__9 9.125
C_67 xbias__XR2__9 VSS 1.8067e-15
R_68_t0 xbias__XR2__7__t0 xbias__XR2__7 9.125
R_68_t1 xbias__XR2__7__t1 xbias__XR2__7 9.125
C_68 xbias__XR2__7 VSS 1.8067e-15
R_69_t0 xbias__XR2__5__t0 xbias__XR2__5 9.125
R_69_t1 xbias__XR2__5__t1 xbias__XR2__5 9.125
C_69 xbias__XR2__5 VSS 1.8067e-15
R_7_t0 xbias__NBTOP__t0 xbias__NBTOP 3898.24002795
R_7_t1 xbias__NBTOP__t1 xbias__NBTOP 2571.04128444
R_7_t2 xbias__NBTOP__t2 xbias__NBTOP 1327.4843876
C_7 xbias__NBTOP VSS 7.8319844e-14
R_70_t0 xbias__XR2__3__t0 xbias__XR2__3 9.125
R_70_t1 xbias__XR2__3__t1 xbias__XR2__3 9.125
C_70 xbias__XR2__3 VSS 1.8067e-15
R_71_t0 xbias__XR2__1__t0 xbias__XR2__1 9.125
R_71_t1 xbias__XR2__1__t1 xbias__XR2__1 9.125
C_71 xbias__XR2__1 VSS 1.8067e-15
R_8_t0 xbias__NBG__t0 xbias__NBG 2435.8789
R_8_t1 xbias__NBG__t1 xbias__NBG 967.291041449
R_8_t2 xbias__NBG__t2 xbias__NBG 734.293929275
R_8_t3 xbias__NBG__t3 xbias__NBG 734.293929275
C_8 xbias__NBG VSS 5.5851412e-14
R_9_t0 xbias__PB__t0 xbias__PB 732.273832504
R_9_t1 xbias__PB__t1 xbias__PB 171.628406437
R_9_t2 xbias__PB__t2 xbias__PB 1341.19339542
R_9_t3 xbias__PB__t3 xbias__PB 321.870246222
R_9_t4 xbias__PB__t4 xbias__PB 783.709475137
R_9_t5 xbias__PB__t5 xbias__PB 769.394856997
R_9_t6 xbias__PB__t6 xbias__PB 769.394856997
R_9_t7 xbias__PB__t7 xbias__PB 460.379603783
R_9_t8 xbias__PB__t8 xbias__PB 46.1556265021
C_9 xbias__PB VSS 7.9168117e-14
R_95_t0 xtemp__XRZ__2__t0 xtemp__XRZ__2 25.28745
R_95_t1 xtemp__XRZ__2__t1 xtemp__XRZ__2 25.28745
C_95 xtemp__XRZ__2 VSS 1.599507e-15
R_96_t0 xtemp__XRZ__4__t0 xtemp__XRZ__4 25.28745
R_96_t1 xtemp__XRZ__4__t1 xtemp__XRZ__4 25.28745
C_96 xtemp__XRZ__4 VSS 1.599507e-15
R_97_t0 xtemp__XRZ__6__t0 xtemp__XRZ__6 25.28745
R_97_t1 xtemp__XRZ__6__t1 xtemp__XRZ__6 25.28745
C_97 xtemp__XRZ__6 VSS 1.599507e-15
R_98_t0 xtemp__XRZ__8__t0 xtemp__XRZ__8 25.28745
R_98_t1 xtemp__XRZ__8__t1 xtemp__XRZ__8 25.28745
C_98 xtemp__XRZ__8 VSS 1.599507e-15
R_99_t0 xtemp__XR2F__2__t0 xtemp__XR2F__2 25.28745
R_99_t1 xtemp__XR2F__2__t1 xtemp__XR2F__2 25.28745
C_99 xtemp__XR2F__2 VSS 1.599507e-15
RBIAS_OK_t0 BIAS_OK__t0 BIAS_OK 984.154042318
RBIAS_OK_t1 BIAS_OK__t1 BIAS_OK 1113.02244149
RBIAS_OK_t2 BIAS_OK__t2 BIAS_OK 1113.14438776
RBIAS_OK_t3 BIAS_OK__t3 BIAS_OK 901.35693696
RBIAS_OK_t4 BIAS_OK__t4 BIAS_OK 2143.19269147
CBIAS_OK BIAS_OK VSS 1.00869418e-13
RBIAS_OKB_t0 xcmp__BIAS_OKB__t0 xcmp__BIAS_OKB 744.308889961
RBIAS_OKB_t1 xcmp__BIAS_OKB__t1 xcmp__BIAS_OKB 59.9080526262
RBIAS_OKB_t2 xcmp__BIAS_OKB__t2 xcmp__BIAS_OKB 17.0676522536
RBIAS_OKB_t3 xcmp__BIAS_OKB__t3 xcmp__BIAS_OKB 349.031750011
RBIAS_OKB_t4 xcmp__BIAS_OKB__t4 xcmp__BIAS_OKB 351.14495704
RBIAS_OKB_t5 xcmp__BIAS_OKB__t5 xcmp__BIAS_OKB 109.722398109
CBIAS_OKB xcmp__BIAS_OKB VSS 2.1654538e-14
RCTAT_t0 CTAT__t0 CTAT 270.83535
RCTAT_t1 CTAT__t1 CTAT 270.83535
CCTAT CTAT VSS 4.4056706e-14
REN_RESETn_t0 RESETn__t0 RESETn 791.24889891
REN_RESETn_t1 RESETn__t1 RESETn 779.942668296
REN_RESETn_t2 RESETn__t2 RESETn 737.918009822
REN_RESETn_t3 RESETn__t3 RESETn 798.873287602
REN_RESETn_t4 RESETn__t4 RESETn 634.332156697
REN_RESETn_t5 RESETn__t5 RESETn 783.76754696
REN_RESETn_t6 RESETn__t6 RESETn 717.713144061
REN_RESETn_t7 RESETn__t7 RESETn 765.302787652
CEN_RESETn RESETn VSS 2.04212856e-13
RENB_t0 xtemp__ENB__t0 xtemp__ENB 171.908381309
RENB_t1 xtemp__ENB__t1 xtemp__ENB 163.414676184
RENB_t2 xtemp__ENB__t2 xtemp__ENB 137.876093758
RENB_t3 xtemp__ENB__t3 xtemp__ENB 421.059618338
RENB_t4 xtemp__ENB__t4 xtemp__ENB 95.6628742538
RENB_t5 xtemp__ENB__t5 xtemp__ENB 326.623923902
RENB_t6 xtemp__ENB__t6 xtemp__ENB 189.999228044
RENB_t7 xtemp__ENB__t7 xtemp__ENB 215.772604212
CENB xtemp__ENB VSS 3.6396628e-14
RIBIAS_t0 IBIAS__t0 IBIAS 1846.56371411
RIBIAS_t1 IBIAS__t1 IBIAS 358.156513217
RIBIAS_t2 IBIAS__t2 IBIAS 349.862548376
RIBIAS_t3 IBIAS__t3 IBIAS 1544.2520408
RIBIAS_t4 IBIAS__t4 IBIAS 1544.2520408
RIBIAS_t5 IBIAS__t5 IBIAS 1608.43360795
RIBIAS_t6 IBIAS__t6 IBIAS 1695.92709525
RIBIAS_t7 IBIAS__t7 IBIAS 1689.27684279
RIBIAS_t8 IBIAS__t8 IBIAS 353.907996709
CIBIAS IBIAS VSS 2.41547289e-13
RM1D_t0 xtemp__M1D__t0 xtemp__M1D 365.905392247
RM1D_t1 xtemp__M1D__t1 xtemp__M1D 365.905392247
RM1D_t2 xtemp__M1D__t2 xtemp__M1D 297.344707753
RM1D_t3 xtemp__M1D__t3 xtemp__M1D 297.344707753
CM1D xtemp__M1D VSS 2.6572254e-14
RM2D_t0 xtemp__M2D__t0 xtemp__M2D 367.857221648
RM2D_t1 xtemp__M2D__t1 xtemp__M2D 367.857221648
RM2D_t2 xtemp__M2D__t2 xtemp__M2D 257.619878352
RM2D_t3 xtemp__M2D__t3 xtemp__M2D 257.619878352
CM2D xtemp__M2D VSS 2.5181332e-14
RM3D_t0 xtemp__M3D__t0 xtemp__M3D 469.402264286
RM3D_t1 xtemp__M3D__t1 xtemp__M3D 469.402264286
RM3D_t2 xtemp__M3D__t2 xtemp__M3D 118.304635714
RM3D_t3 xtemp__M3D__t3 xtemp__M3D 118.304635714
CM3D xtemp__M3D VSS 2.3790409e-14
RN1_t0 xtemp__N1__t0 xtemp__N1 534.627163629
RN1_t1 xtemp__N1__t1 xtemp__N1 378.085819054
RN1_t2 xtemp__N1__t2 xtemp__N1 243.963010283
RN1_t3 xtemp__N1__t3 xtemp__N1 188.503038543
RN1_t4 xtemp__N1__t4 xtemp__N1 534.627163629
RN1_t5 xtemp__N1__t5 xtemp__N1 188.503038543
RN1_t6 xtemp__N1__t6 xtemp__N1 1046.59861862
RN1_t7 xtemp__N1__t7 xtemp__N1 801.166547704
CN1 xtemp__N1 VSS 3.9158003e-14
RN2_t0 xtemp__N2__t0 xtemp__N2 667.28572049
RN2_t1 xtemp__N2__t1 xtemp__N2 392.018582259
RN2_t2 xtemp__N2__t2 xtemp__N2 145.839569879
RN2_t3 xtemp__N2__t3 xtemp__N2 198.053465004
RN2_t4 xtemp__N2__t4 xtemp__N2 225.570429521
RN2_t5 xtemp__N2__t5 xtemp__N2 356.362337093
RN2_t6 xtemp__N2__t6 xtemp__N2 374.421195754
CN2 xtemp__N2 VSS 5.5687914e-14
RNA_t0 xtemp__NA__t0 xtemp__NA 299.987016677
RNA_t1 xtemp__NA__t1 xtemp__NA 782.211458547
RNA_t2 xtemp__NA__t2 xtemp__NA 91.0640100894
RNA_t3 xtemp__NA__t3 xtemp__NA 177.9098074
RNA_t4 xtemp__NA__t4 xtemp__NA 432.588253149
RNA_t5 xtemp__NA__t5 xtemp__NA 389.407654138
CNA xtemp__NA VSS 7.726204e-14
RNB_t0 xtemp__NB__t0 xtemp__NB 875.385865849
RNB_t1 xtemp__NB__t1 xtemp__NB 66.6687788692
RNB_t2 xtemp__NB__t2 xtemp__NB 134.537436555
RNB_t3 xtemp__NB__t3 xtemp__NB 481.341493586
RNB_t4 xtemp__NB__t4 xtemp__NB 509.685725141
CNB xtemp__NB VSS 4.7120272e-14
RNBG_t0 xtemp__NBG__t0 xtemp__NBG 319.655393327
RNBG_t1 xtemp__NBG__t1 xtemp__NBG 497.957181646
RNBG_t2 xtemp__NBG__t2 xtemp__NBG 72.3456579667
RNBG_t3 xtemp__NBG__t3 xtemp__NBG 74.3376726087
RNBG_t4 xtemp__NBG__t4 xtemp__NBG 180.635494451
CNBG xtemp__NBG VSS 2.6929172e-14
RNC_t0 xtemp__NC__t0 xtemp__NC 58.0128241616
RNC_t1 xtemp__NC__t1 xtemp__NC 5.17314575229
RNC_t2 xtemp__NC__t2 xtemp__NC 8.42906808227
RNC_t3 xtemp__NC__t3 xtemp__NC 12.3918471968
RNC_t4 xtemp__NC__t4 xtemp__NC 2.88062399517
RNC_t5 xtemp__NC__t5 xtemp__NC 12.4439514887
RNC_t6 xtemp__NC__t6 xtemp__NC 8.50548296342
RNC_t7 xtemp__NC__t7 xtemp__NC 5.29674321447
RNC_t8 xtemp__NC__t8 xtemp__NC 11.6230131453
CNC xtemp__NC VSS 1.06239997e-13
RND_t0 xtemp__ND__t0 xtemp__ND 229.124892636
RND_t1 xtemp__ND__t1 xtemp__ND 685.527951368
RND_t2 xtemp__ND__t2 xtemp__ND 219.61306336
RND_t3 xtemp__ND__t3 xtemp__ND 378.405592635
CND xtemp__ND VSS 3.4731319e-14
RNR_t0 xtemp__NR__t0 xtemp__NR 286.922700175
RNR_t1 xtemp__NR__t1 xtemp__NR 286.922700175
RNR_t2 xtemp__NR__t2 xtemp__NR 356.720721034
RNR_t3 xtemp__NR__t3 xtemp__NR 764.350678615
CNR xtemp__NR VSS 3.5361036e-14
RNT_t0 xtemp__NT__t0 xtemp__NT 97.5193258677
RNT_t1 xtemp__NT__t1 xtemp__NT 2593.74803582
RNT_t2 xtemp__NT__t2 xtemp__NT 330.085678635
RNT_t3 xtemp__NT__t3 xtemp__NT 24.5247259175
RNT_t4 xtemp__NT__t4 xtemp__NT 330.085678635
RNT_t5 xtemp__NT__t5 xtemp__NT 24.5247259175
RNT_t6 xtemp__NT__t6 xtemp__NT 134.599552202
RNT_t7 xtemp__NT__t7 xtemp__NT 199.46944143
RNT_t8 xtemp__NT__t8 xtemp__NT 264.703412634
RNT_t9 xtemp__NT__t9 xtemp__NT 330.085678635
RNT_t10 xtemp__NT__t10 xtemp__NT 71.0974037861
RNT_t11 xtemp__NT__t11 xtemp__NT 24.5247259175
RNT_t12 xtemp__NT__t12 xtemp__NT 134.599552202
RNT_t13 xtemp__NT__t13 xtemp__NT 199.46944143
RNT_t14 xtemp__NT__t14 xtemp__NT 264.703412634
RNT_t15 xtemp__NT__t15 xtemp__NT 330.085678635
RNT_t16 xtemp__NT__t16 xtemp__NT 71.0974037861
RNT_t17 xtemp__NT__t17 xtemp__NT 24.5247259175
CNT xtemp__NT VSS 8.5988494e-14
RNZ_t0 xtemp__NZ__t0 xtemp__NZ 59.5605
RNZ_t1 xtemp__NZ__t1 xtemp__NZ 59.5605
CNZ xtemp__NZ VSS 3.4541994e-14
RPB_t0 xtemp__PB__t0 xtemp__PB 1632.9207003
RPB_t1 xtemp__PB__t1 xtemp__PB 118.157609212
RPB_t2 xtemp__PB__t2 xtemp__PB 328.441785264
RPB_t3 xtemp__PB__t3 xtemp__PB 645.862714873
RPB_t4 xtemp__PB__t4 xtemp__PB 328.441785264
RPB_t5 xtemp__PB__t5 xtemp__PB 481.85070509
CPB xtemp__PB VSS 4.7116177e-14
RPCAS_t0 xtemp__PCAS__t0 xtemp__PCAS 810.502975562
RPCAS_t1 xtemp__PCAS__t1 xtemp__PCAS 758.177517915
RPCAS_t2 xtemp__PCAS__t2 xtemp__PCAS 758.177517915
RPCAS_t3 xtemp__PCAS__t3 xtemp__PCAS 101.088066233
RPCAS_t4 xtemp__PCAS__t4 xtemp__PCAS 648.949250633
RPCAS_t5 xtemp__PCAS__t5 xtemp__PCAS 389.130532764
RPCAS_t6 xtemp__PCAS__t6 xtemp__PCAS 518.763990671
RPCAS_t7 xtemp__PCAS__t7 xtemp__PCAS 218.391841544
RPCAS_t8 xtemp__PCAS__t8 xtemp__PCAS 345.683006763
CPCAS xtemp__PCAS VSS 5.3717376e-14
RPG_t0 xtemp__PG__t0 xtemp__PG 666.150692096
RPG_t1 xtemp__PG__t1 xtemp__PG 430.615978181
RPG_t2 xtemp__PG__t2 xtemp__PG 83.6375011211
RPG_t3 xtemp__PG__t3 xtemp__PG 417.439404629
RPG_t4 xtemp__PG__t4 xtemp__PG 599.142193276
RPG_t5 xtemp__PG__t5 xtemp__PG 514.848951694
RPG_t6 xtemp__PG__t6 xtemp__PG 151.271388757
RPG_t7 xtemp__PG__t7 xtemp__PG 234.368666133
RPG_t8 xtemp__PG__t8 xtemp__PG 318.177485975
RPG_t9 xtemp__PG__t9 xtemp__PG 731.227109932
RPG_t10 xtemp__PG__t10 xtemp__PG 334.099181493
RPG_t11 xtemp__PG__t11 xtemp__PG 629.340446714
CPG xtemp__PG VSS 6.8097327e-14
RPOR_RAW_t0 POR_RAW__t0 POR_RAW 1629.67210898
RPOR_RAW_t1 POR_RAW__t1 POR_RAW 1233.22826717
RPOR_RAW_t2 POR_RAW__t2 POR_RAW 1092.40942032
RPOR_RAW_t3 POR_RAW__t3 POR_RAW 1488.85430353
CPOR_RAW POR_RAW VSS 9.050824e-14
RPTAT_t0 PTAT__t0 PTAT 384.810019591
RPTAT_t1 PTAT__t1 PTAT 164.836688938
RPTAT_t2 PTAT__t2 PTAT 226.741568323
RPTAT_t3 PTAT__t3 PTAT 218.610523147
CPTAT PTAT VSS 5.1111964e-14
RT0_t0 xtemp__T0__t0 xtemp__T0 320.043026094
RT0_t1 xtemp__T0__t1 xtemp__T0 313.559674231
RT0_t2 xtemp__T0__t2 xtemp__T0 312.817780188
RT0_t3 xtemp__T0__t3 xtemp__T0 320.719719486
CT0 xtemp__T0 VSS 6.0943107e-14
RT1_t0 xtemp__T1__t0 xtemp__T1 309.075824733
RT1_t1 xtemp__T1__t1 xtemp__T1 305.716375402
RT1_t2 xtemp__T1__t2 xtemp__T1 315.094088938
RT1_t3 xtemp__T1__t3 xtemp__T1 299.558010926
CT1 xtemp__T1 VSS 6.0274424e-14
RT2_t0 xtemp__T2__t0 xtemp__T2 296.459639641
RT2_t1 xtemp__T2__t1 xtemp__T2 299.620848801
RT2_t2 xtemp__T2__t2 xtemp__T2 286.687901974
RT2_t3 xtemp__T2__t3 xtemp__T2 308.985109584
CT2 xtemp__T2 VSS 5.9605742e-14
RT3_t0 xtemp__T3__t0 xtemp__T3 280.061751539
RT3_t1 xtemp__T3__t1 xtemp__T3 297.643350284
RT3_t2 xtemp__T3__t2 xtemp__T3 301.967758756
RT3_t3 xtemp__T3__t3 xtemp__T3 274.39563942
CT3 xtemp__T3 VSS 5.8937059e-14
RT4_t0 xtemp__T4__t0 xtemp__T4 292.687741783
RT4_t1 xtemp__T4__t1 xtemp__T4 256.490260142
RT4_t2 xtemp__T4__t2 xtemp__T4 303.654865819
RT4_t3 xtemp__T4__t3 xtemp__T4 263.556832256
CT4 xtemp__T4 VSS 5.8268377e-14
RT5_t0 xtemp__T5__t0 xtemp__T5 311.783920291
RT5_t1 xtemp__T5__t1 xtemp__T5 160.212156364
RT5_t2 xtemp__T5__t2 xtemp__T5 151.573623345
CT5 xtemp__T5 VSS 5.1212691e-14
RVDD_t0 VDD__t0 VDD 65.2196284139
RVDD_t1 VDD__t1 VDD 111.778676745
RVDD_t2 VDD__t2 VDD 111.778676745
RVDD_t3 VDD__t3 VDD 107.275072116
RVDD_t4 VDD__t4 VDD 107.275072116
RVDD_t5 VDD__t5 VDD 101.94806792
RVDD_t6 VDD__t6 VDD 101.94806792
RVDD_t7 VDD__t7 VDD 100.075862715
RVDD_t8 VDD__t8 VDD 96.2690313262
RVDD_t9 VDD__t9 VDD 96.2690313262
RVDD_t10 VDD__t10 VDD 75.7792586374
RVDD_t11 VDD__t11 VDD 75.7792586374
RVDD_t12 VDD__t12 VDD 48.8200904995
RVDD_t13 VDD__t13 VDD 49.5355972853
RVDD_t14 VDD__t14 VDD 49.5355972853
RVDD_t15 VDD__t15 VDD 50.1182660872
RVDD_t16 VDD__t16 VDD 50.1182660872
RVDD_t17 VDD__t17 VDD 179.00486924
RVDD_t18 VDD__t18 VDD 179.00486924
RVDD_t19 VDD__t19 VDD 185.288298454
RVDD_t20 VDD__t20 VDD 185.288298454
RVDD_t21 VDD__t21 VDD 188.876304233
RVDD_t22 VDD__t22 VDD 188.876304233
RVDD_t23 VDD__t23 VDD 194.186876568
RVDD_t24 VDD__t24 VDD 195.206467814
RVDD_t25 VDD__t25 VDD 195.206467814
RVDD_t26 VDD__t26 VDD 197.037700427
RVDD_t27 VDD__t27 VDD 197.977292435
RVDD_t28 VDD__t28 VDD 203.859238701
RVDD_t29 VDD__t29 VDD 203.859238701
RVDD_t30 VDD__t30 VDD 36.5662970865
RVDD_t31 VDD__t31 VDD 58.3274659726
RVDD_t32 VDD__t32 VDD 58.3274659726
RVDD_t33 VDD__t33 VDD 117.567986315
RVDD_t34 VDD__t34 VDD 102.663034504
RVDD_t35 VDD__t35 VDD 102.663034504
RVDD_t36 VDD__t36 VDD 117.567986315
RVDD_t37 VDD__t37 VDD 89.4677926207
RVDD_t38 VDD__t38 VDD 89.4677926207
RVDD_t39 VDD__t39 VDD 83.6518696905
RVDD_t40 VDD__t40 VDD 83.6518696905
RVDD_t41 VDD__t41 VDD 81.5256534
RVDD_t42 VDD__t42 VDD 81.5256534
RVDD_t43 VDD__t43 VDD 86.4511067433
RVDD_t44 VDD__t44 VDD 86.4511067433
RVDD_t45 VDD__t45 VDD 101.487726192
RVDD_t46 VDD__t46 VDD 99.7397211536
RVDD_t47 VDD__t47 VDD 98.0226921631
RVDD_t48 VDD__t48 VDD 92.5391522041
RVDD_t49 VDD__t49 VDD 91.4987483055
RVDD_t50 VDD__t50 VDD 94.1403475151
RVDD_t51 VDD__t51 VDD 95.778380467
RVDD_t52 VDD__t52 VDD 101.487726192
RVDD_t53 VDD__t53 VDD 99.7397211536
RVDD_t54 VDD__t54 VDD 98.0226921631
RVDD_t55 VDD__t55 VDD 92.5391522041
RVDD_t56 VDD__t56 VDD 91.4987483055
RVDD_t57 VDD__t57 VDD 94.1403475151
RVDD_t58 VDD__t58 VDD 95.778380467
RVDD_t59 VDD__t59 VDD 102.663034504
RVDD_t60 VDD__t60 VDD 91.4987483055
RVDD_t61 VDD__t61 VDD 102.663034504
RVDD_t62 VDD__t62 VDD 91.4987483055
RVDD_t63 VDD__t63 VDD 64.3107217481
RVDD_t64 VDD__t64 VDD 197.977292435
RVDD_t65 VDD__t65 VDD 192.157035573
RVDD_t66 VDD__t66 VDD 201.757654764
RVDD_t67 VDD__t67 VDD 192.157035573
RVDD_t68 VDD__t68 VDD 201.757654764
RVDD_t69 VDD__t69 VDD 182.275223496
RVDD_t70 VDD__t70 VDD 182.275223496
RVDD_t71 VDD__t71 VDD 196.163586251
RVDD_t72 VDD__t72 VDD 50.4663839903
RVDD_t73 VDD__t73 VDD 82.8658439717
RVDD_t74 VDD__t74 VDD 196.163586251
RVDD_t75 VDD__t75 VDD 50.4663839903
RVDD_t76 VDD__t76 VDD 82.8658439717
RVDD_t77 VDD__t77 VDD 78.5974872418
RVDD_t78 VDD__t78 VDD 199.600157085
RVDD_t79 VDD__t79 VDD 198.790415344
RVDD_t80 VDD__t80 VDD 78.5974872418
RVDD_t81 VDD__t81 VDD 199.600157085
RVDD_t82 VDD__t82 VDD 198.790415344
RVDD_t83 VDD__t83 VDD 93.3350256392
RVDD_t84 VDD__t84 VDD 100.609951905
RVDD_t85 VDD__t85 VDD 97.1763079592
RVDD_t86 VDD__t86 VDD 49.183189221
RVDD_t87 VDD__t87 VDD 98.8772331124
RVDD_t88 VDD__t88 VDD 94.9548774324
RVDD_t89 VDD__t89 VDD 96.6106271605
RVDD_t90 VDD__t90 VDD 79.5545293736
RVDD_t91 VDD__t91 VDD 94.7154807987
RVDD_t92 VDD__t92 VDD 90.1028817945
RVDD_t93 VDD__t93 VDD 88.5827564131
RVDD_t94 VDD__t94 VDD 79.5545293736
RVDD_t95 VDD__t95 VDD 94.7154807987
RVDD_t96 VDD__t96 VDD 90.1028817945
RVDD_t97 VDD__t97 VDD 88.5827564131
RVDD_t98 VDD__t98 VDD 98.4868751243
RVDD_t99 VDD__t99 VDD 105.67567296
RVDD_t100 VDD__t100 VDD 102.493760826
RVDD_t101 VDD__t101 VDD 97.7672226743
RVDD_t102 VDD__t102 VDD 105.67567296
RVDD_t103 VDD__t103 VDD 102.493760826
RVDD_t104 VDD__t104 VDD 97.7672226743
RVDD_t105 VDD__t105 VDD 92.7116499631
RVDD_t106 VDD__t106 VDD 110.159292373
RVDD_t107 VDD__t107 VDD 108.544629975
RVDD_t108 VDD__t108 VDD 91.1662531156
RVDD_t109 VDD__t109 VDD 110.159292373
RVDD_t110 VDD__t110 VDD 108.544629975
CVDD VDD VSS 7.69270398e-13
RVREF_t0 VREF__t0 VREF 1775.35275264
RVREF_t1 VREF__t1 VREF 3191.00030505
RVREF_t2 VREF__t2 VREF 4179.70894231
CVREF VREF VSS 1.27500974e-13
RVSS_t0 VSS__t0 VSS 25.2154251916
RVSS_t1 VSS__t1 VSS 19.1725636954
RVSS_t2 VSS__t2 VSS 18.5496443538
RVSS_t3 VSS__t3 VSS 17.6792311862
RVSS_t4 VSS__t4 VSS 15.3047177725
RVSS_t5 VSS__t5 VSS 15.2349536978
RVSS_t6 VSS__t6 VSS 14.6663253377
RVSS_t7 VSS__t7 VSS 14.3419763563
RVSS_t8 VSS__t8 VSS 12.5734242329
RVSS_t9 VSS__t9 VSS 12.6838927664
RVSS_t10 VSS__t10 VSS 12.802239454
RVSS_t11 VSS__t11 VSS 12.8857380219
RVSS_t12 VSS__t12 VSS 12.7378189321
RVSS_t13 VSS__t13 VSS 13.0769454302
RVSS_t14 VSS__t14 VSS 13.3029489567
RVSS_t15 VSS__t15 VSS 28.4326543923
RVSS_t16 VSS__t16 VSS 29.2516424815
RVSS_t17 VSS__t17 VSS 30.1611595813
RVSS_t18 VSS__t18 VSS 30.6658704726
RVSS_t19 VSS__t19 VSS 31.4450703782
RVSS_t20 VSS__t20 VSS 32.0129633638
RVSS_t21 VSS__t21 VSS 13.6083051134
RVSS_t22 VSS__t22 VSS 11.5696809269
RVSS_t23 VSS__t23 VSS 11.6627231316
RVSS_t24 VSS__t24 VSS 9.89391678895
RVSS_t25 VSS__t25 VSS 28.1811696252
RVSS_t26 VSS__t26 VSS 30.8402844553
RVSS_t27 VSS__t27 VSS 11.5523088217
RVSS_t28 VSS__t28 VSS 13.0647736526
RVSS_t29 VSS__t29 VSS 13.3389594093
RVSS_t30 VSS__t30 VSS 13.6440200053
RVSS_t31 VSS__t31 VSS 13.7224501514
RVSS_t32 VSS__t32 VSS 14.9126071928
RVSS_t33 VSS__t33 VSS 14.6340154949
RVSS_t34 VSS__t34 VSS 14.38453621
RVSS_t35 VSS__t35 VSS 14.2750344822
RVSS_t36 VSS__t36 VSS 13.9837464825
RVSS_t37 VSS__t37 VSS 29.1692129494
RVSS_t38 VSS__t38 VSS 27.6852376712
RVSS_t39 VSS__t39 VSS 29.6403259197
RVSS_t40 VSS__t40 VSS 9.71858231973
RVSS_t41 VSS__t41 VSS 9.63238211599
RVSS_t42 VSS__t42 VSS 9.5471953547
RVSS_t43 VSS__t43 VSS 9.80576923915
RVSS_t44 VSS__t44 VSS 9.71858231973
RVSS_t45 VSS__t45 VSS 11.5548466517
RVSS_t46 VSS__t46 VSS 11.9056668408
RVSS_t47 VSS__t47 VSS 12.2928436123
RVSS_t48 VSS__t48 VSS 12.2371587287
RVSS_t49 VSS__t49 VSS 12.5689488633
RVSS_t50 VSS__t50 VSS 12.9362891387
RVSS_t51 VSS__t51 VSS 10.8820764523
RVSS_t52 VSS__t52 VSS 11.2538886476
RVSS_t53 VSS__t53 VSS 11.2437866727
RVSS_t54 VSS__t54 VSS 12.8266953617
RVSS_t55 VSS__t55 VSS 13.2322265468
RVSS_t56 VSS__t56 VSS 13.1392890586
RVSS_t57 VSS__t57 VSS 12.2544548492
RVSS_t58 VSS__t58 VSS 38.20460511
RVSS_t59 VSS__t59 VSS 32.3862625376
RVSS_t60 VSS__t60 VSS 10.8648631224
RVSS_t61 VSS__t61 VSS 32.5545001769
RVSS_t62 VSS__t62 VSS 31.6309498602
RVSS_t63 VSS__t63 VSS 10.9701025902
RVSS_t64 VSS__t64 VSS 32.8470787364
RVSS_t65 VSS__t65 VSS 13.3971222922
RVSS_t66 VSS__t66 VSS 31.2517242274
RVSS_t67 VSS__t67 VSS 11.1398519041
RVSS_t68 VSS__t68 VSS 11.2572904484
RVSS_t69 VSS__t69 VSS 11.7358241073
RVSS_t70 VSS__t70 VSS 17.5094765144
RVSS_t71 VSS__t71 VSS 19.8044402545
RVSS_t72 VSS__t72 VSS 17.5094765144
RVSS_t73 VSS__t73 VSS 19.8044402545
RVSS_t74 VSS__t74 VSS 10.7420373936
RVSS_t75 VSS__t75 VSS 10.6391134837
RVSS_t76 VSS__t76 VSS 12.9881179569
RVSS_t77 VSS__t77 VSS 14.094998376
RVSS_t78 VSS__t78 VSS 18.1448078253
RVSS_t79 VSS__t79 VSS 17.5094765144
RVSS_t80 VSS__t80 VSS 17.9631868318
RVSS_t81 VSS__t81 VSS 18.4197352432
RVSS_t82 VSS__t82 VSS 18.8789158488
RVSS_t83 VSS__t83 VSS 19.3405411699
RVSS_t84 VSS__t84 VSS 19.8044402545
RVSS_t85 VSS__t85 VSS 18.9146292267
RVSS_t86 VSS__t86 VSS 15.0130039682
RVSS_t87 VSS__t87 VSS 15.6326892074
RVSS_t88 VSS__t88 VSS 14.8155646838
RVSS_t89 VSS__t89 VSS 14.5200851326
RVSS_t90 VSS__t90 VSS 12.9362891387
RVSS_t91 VSS__t91 VSS 12.5689488633
RVSS_t92 VSS__t92 VSS 12.2371587287
RVSS_t93 VSS__t93 VSS 12.2928436123
RVSS_t94 VSS__t94 VSS 11.9056668408
RVSS_t95 VSS__t95 VSS 11.5548466517
RVSS_t96 VSS__t96 VSS 11.2437866727
RVSS_t97 VSS__t97 VSS 11.6627231316
RVSS_t98 VSS__t98 VSS 11.2538886476
RVSS_t99 VSS__t99 VSS 10.8820764523
RVSS_t100 VSS__t100 VSS 13.0647736526
RVSS_t101 VSS__t101 VSS 13.3389594093
RVSS_t102 VSS__t102 VSS 13.6440200053
RVSS_t103 VSS__t103 VSS 13.7224501514
RVSS_t104 VSS__t104 VSS 13.9837464825
RVSS_t105 VSS__t105 VSS 14.2750344822
RVSS_t106 VSS__t106 VSS 14.38453621
RVSS_t107 VSS__t107 VSS 14.6340154949
RVSS_t108 VSS__t108 VSS 14.9126071928
RVSS_t109 VSS__t109 VSS 13.7617539089
RVSS_t110 VSS__t110 VSS 13.7057499348
RVSS_t111 VSS__t111 VSS 13.5523175971
RVSS_t112 VSS__t112 VSS 13.498819105
RVSS_t113 VSS__t113 VSS 14.5038798758
RVSS_t114 VSS__t114 VSS 14.4570547062
RVSS_t115 VSS__t115 VSS 14.4116576867
RVSS_t116 VSS__t116 VSS 14.3677023547
RVSS_t117 VSS__t117 VSS 14.3252019812
RVSS_t118 VSS__t118 VSS 14.2841695533
RVSS_t119 VSS__t119 VSS 14.2446177565
RVSS_t120 VSS__t120 VSS 14.2065589571
RVSS_t121 VSS__t121 VSS 14.1700051853
RVSS_t122 VSS__t122 VSS 14.1349681173
RVSS_t123 VSS__t123 VSS 14.3599636894
RVSS_t124 VSS__t124 VSS 14.3285703486
RVSS_t125 VSS__t125 VSS 14.298700867
RVSS_t126 VSS__t126 VSS 14.2703648135
RVSS_t127 VSS__t127 VSS 14.2435713397
RVSS_t128 VSS__t128 VSS 14.2183291664
RVSS_t129 VSS__t129 VSS 14.1946465695
RVSS_t130 VSS__t130 VSS 14.1725313674
RVSS_t131 VSS__t131 VSS 14.1519909079
RVSS_t132 VSS__t132 VSS 14.1330320573
RVSS_t133 VSS__t133 VSS 14.1156611883
RVSS_t134 VSS__t134 VSS 14.09988417
RVSS_t135 VSS__t135 VSS 14.0857063581
RVSS_t136 VSS__t136 VSS 14.0731325859
RVSS_t137 VSS__t137 VSS 14.0621671562
RVSS_t138 VSS__t138 VSS 14.0528138341
RVSS_t139 VSS__t139 VSS 14.0450758401
RVSS_t140 VSS__t140 VSS 14.0389558454
RVSS_t141 VSS__t141 VSS 14.0344559666
RVSS_t142 VSS__t142 VSS 14.0315777624
RVSS_t143 VSS__t143 VSS 14.0303222308
RVSS_t144 VSS__t144 VSS 14.0306898075
RVSS_t145 VSS__t145 VSS 14.0326803649
RVSS_t146 VSS__t146 VSS 14.0362932126
RVSS_t147 VSS__t147 VSS 14.1503465357
RVSS_t148 VSS__t148 VSS 14.1571469709
RVSS_t149 VSS__t149 VSS 12.7220873656
RVSS_t150 VSS__t150 VSS 12.7332283637
RVSS_t151 VSS__t151 VSS 12.0261535681
RVSS_t152 VSS__t152 VSS 12.0417217049
RVSS_t153 VSS__t153 VSS 11.700251308
RVSS_t154 VSS__t154 VSS 11.7201393761
RVSS_t155 VSS__t155 VSS 11.563042437
RVSS_t156 VSS__t156 VSS 11.5870976122
RVSS_t157 VSS__t157 VSS 11.5242294358
RVSS_t158 VSS__t158 VSS 11.5523088217
RVSS_t159 VSS__t159 VSS 19.5647541138
RVSS_t160 VSS__t160 VSS 25.2154251916
RVSS_t161 VSS__t161 VSS 12.962354262
RVSS_t162 VSS__t162 VSS 5.97346834191
RVSS_t163 VSS__t163 VSS 5.88974384142
RVSS_t164 VSS__t164 VSS 5.73055329037
RVSS_t165 VSS__t165 VSS 5.58315217506
RVSS_t166 VSS__t166 VSS 5.44849741727
RVSS_t167 VSS__t167 VSS 5.32755560289
RVSS_t168 VSS__t168 VSS 5.22127972797
RVSS_t169 VSS__t169 VSS 5.13058125299
RVSS_t170 VSS__t170 VSS 5.80873378441
RVSS_t171 VSS__t171 VSS 5.65531971018
RVSS_t172 VSS__t172 VSS 5.5141710683
RVSS_t173 VSS__t173 VSS 5.38625220505
RVSS_t174 VSS__t174 VSS 5.27252612723
RVSS_t175 VSS__t175 VSS 5.17392881746
RVSS_t176 VSS__t176 VSS 5.09133928881
RVSS_t177 VSS__t177 VSS 5.05629851661
RVSS_t178 VSS__t178 VSS 5.05352459261
RVSS_t179 VSS__t179 VSS 5.033324315
RVSS_t180 VSS__t180 VSS 5.01758345091
RVSS_t181 VSS__t181 VSS 5.00634406415
RVSS_t182 VSS__t182 VSS 6.98465966216
RVSS_t183 VSS__t183 VSS 6.98746246606
RVSS_t184 VSS__t184 VSS 11.1797914745
RVSS_t185 VSS__t185 VSS 11.1883297435
RVSS_t186 VSS__t186 VSS 19.1725636954
RVSS_t187 VSS__t187 VSS 18.9146292267
RVSS_t188 VSS__t188 VSS 15.6326892074
RVSS_t189 VSS__t189 VSS 15.0130039682
RVSS_t190 VSS__t190 VSS 14.8155646838
RVSS_t191 VSS__t191 VSS 14.5200851326
RVSS_t192 VSS__t192 VSS 18.5496443538
RVSS_t193 VSS__t193 VSS 18.1448078253
RVSS_t194 VSS__t194 VSS 19.8044402545
RVSS_t195 VSS__t195 VSS 19.3405411699
RVSS_t196 VSS__t196 VSS 18.8789158488
RVSS_t197 VSS__t197 VSS 18.4197352432
RVSS_t198 VSS__t198 VSS 17.9631868318
RVSS_t199 VSS__t199 VSS 17.5094765144
RVSS_t200 VSS__t200 VSS 17.6792311862
RVSS_t201 VSS__t201 VSS 14.094998376
RVSS_t202 VSS__t202 VSS 17.4079544758
RVSS_t203 VSS__t203 VSS 17.026083458
RVSS_t204 VSS__t204 VSS 16.6525309784
RVSS_t205 VSS__t205 VSS 16.2878693888
RVSS_t206 VSS__t206 VSS 15.9327091746
RVSS_t207 VSS__t207 VSS 15.3047177725
RVSS_t208 VSS__t208 VSS 15.2349536978
RVSS_t209 VSS__t209 VSS 14.6663253377
RVSS_t210 VSS__t210 VSS 12.3883406075
RVSS_t211 VSS__t211 VSS 12.4351506301
RVSS_t212 VSS__t212 VSS 12.9881179569
RVSS_t213 VSS__t213 VSS 10.7420373936
RVSS_t214 VSS__t214 VSS 10.6391134837
RVSS_t215 VSS__t215 VSS 14.3419763563
RVSS_t216 VSS__t216 VSS 12.5734242329
RVSS_t217 VSS__t217 VSS 12.6838927664
RVSS_t218 VSS__t218 VSS 11.7358241073
RVSS_t219 VSS__t219 VSS 11.2572904484
RVSS_t220 VSS__t220 VSS 12.7484030229
RVSS_t221 VSS__t221 VSS 12.802239454
RVSS_t222 VSS__t222 VSS 31.2517242274
RVSS_t223 VSS__t223 VSS 32.7019481989
RVSS_t224 VSS__t224 VSS 32.8470787364
RVSS_t225 VSS__t225 VSS 13.5020333939
RVSS_t226 VSS__t226 VSS 13.3971222922
RVSS_t227 VSS__t227 VSS 11.1398519041
RVSS_t228 VSS__t228 VSS 12.8857380219
RVSS_t229 VSS__t229 VSS 31.6309498602
RVSS_t230 VSS__t230 VSS 32.3862625376
RVSS_t231 VSS__t231 VSS 32.5545001769
RVSS_t232 VSS__t232 VSS 10.9701025902
RVSS_t233 VSS__t233 VSS 10.8648631224
RVSS_t234 VSS__t234 VSS 12.7378189321
RVSS_t235 VSS__t235 VSS 38.20460511
RVSS_t236 VSS__t236 VSS 13.0769454302
RVSS_t237 VSS__t237 VSS 13.1392890586
RVSS_t238 VSS__t238 VSS 31.1174773054
RVSS_t239 VSS__t239 VSS 12.2544548492
RVSS_t240 VSS__t240 VSS 13.3029489567
RVSS_t241 VSS__t241 VSS 28.4326543923
RVSS_t242 VSS__t242 VSS 29.2516424815
RVSS_t243 VSS__t243 VSS 30.1611595813
RVSS_t244 VSS__t244 VSS 30.6658704726
RVSS_t245 VSS__t245 VSS 31.4450703782
RVSS_t246 VSS__t246 VSS 32.0129633638
RVSS_t247 VSS__t247 VSS 13.6083051134
RVSS_t248 VSS__t248 VSS 13.2322265468
RVSS_t249 VSS__t249 VSS 12.8266953617
RVSS_t250 VSS__t250 VSS 11.5696809269
RVSS_t251 VSS__t251 VSS 9.98299952275
RVSS_t252 VSS__t252 VSS 9.89391678895
RVSS_t253 VSS__t253 VSS 9.80576923915
RVSS_t254 VSS__t254 VSS 9.71858231973
RVSS_t255 VSS__t255 VSS 9.63238211599
RVSS_t256 VSS__t256 VSS 9.5471953547
CVSS VSS VSS 2.188762023e-12
Ccc__13__6 xbias__N2 xbias__PG 1.1805e-17
Ccc__18__6 xbias__NB xbias__PG 1.1805e-17
Ccc__25__27 xcmp__SNS xcmp__SNSB 1.8889e-17
Ccc__25_BIAS_OK xcmp__SNS BIAS_OK 9.444e-18
Ccc__25_BIAS_OKB xcmp__SNS xcmp__BIAS_OKB 9.444e-18
Ccc__25_VDD xcmp__SNS VDD 9.444e-18
Ccc__27_VDD xcmp__SNSB VDD 9.444e-18
Ccc__31__47 xpor__PGDG xpor__NDG 4.7222e-17
Ccc__32__47 xpor__PGDGB xpor__NDG 4.7222e-17
Ccc__33__47 xpor__ND1 xpor__NDG 4.7222e-17
Ccc__33__48 xpor__ND1 xpor__TIM 4.7222e-17
Ccc__34__47 xpor__NNAND xpor__NDG 2.3611e-17
Ccc__34__48 xpor__NNAND xpor__TIM 2.3611e-17
Ccc__36__47 xpor__NTS xpor__NDG 2.3611e-17
Ccc__37__47 xpor__RSTB xpor__NDG 7.0832e-17
Ccc__37__48 xpor__RSTB xpor__TIM 7.0832e-17
Ccc__40__45 xbias__NOKX xbias__NZ 1.4757e-17
Ccc__40__6 xbias__NOKX xbias__PG 1.4757e-17
Ccc__40_VDD xbias__NOKX VDD 7.7718e-17
Ccc__45__6 xbias__NZ xbias__PG 2.30203e-16
Ccc__46__6 xbias__EC xbias__PG 1.5347e-16
Ccc__47__48 xpor__NDG xpor__TIM 5.0173e-17
Ccc__47__49 xpor__NDG xpor__TRIP 4.7222e-17
Ccc__47_EN_RESETn xpor__NDG RESETn 6.0208e-17
Ccc__47_VDD xpor__NDG VDD 1.5347e-16
Ccc__47_VSS xpor__NDG VSS 3.269281e-15
Ccc__48__49 xpor__TIM xpor__TRIP 4.7222e-17
Ccc__48_EN_RESETn xpor__TIM RESETn 6.0208e-17
Ccc__48_VDD xpor__TIM VDD 1.5347e-16
Ccc__48_VSS xpor__TIM VSS 7.8531938e-14
Ccc__59__6 xbias__NA xbias__PG 1.1805e-17
Ccc__6__7 xbias__PG xbias__NBTOP 1.1805e-17
Ccc__6_VREF xbias__PG VREF 1.1805e-17
Ccc__6_VSS xbias__PG VSS 3.5416e-17
Ccc_BIAS_OK_IBIAS BIAS_OK IBIAS 1.1428e-17
Ccc_BIAS_OK_POR_RAW BIAS_OK POR_RAW 1.1428e-17
Ccc_BIAS_OK_VDD BIAS_OK VDD 2.2855e-17
Ccc_BIAS_OK_VREF BIAS_OK VREF 1.1428e-17
Ccc_BIAS_OK_VSS BIAS_OK VSS 3.4283e-17
Ccc_CTAT_NA CTAT xtemp__NA 8.311e-18
Ccc_CTAT_NB CTAT xtemp__NB 8.311e-18
Ccc_CTAT_NC CTAT xtemp__NC 8.311e-18
Ccc_CTAT_NT CTAT xtemp__NT 8.311e-18
Ccc_CTAT_NZ CTAT xtemp__NZ 8.311e-18
Ccc_CTAT_PTAT CTAT PTAT 8.311e-18
Ccc_CTAT_T0 CTAT xtemp__T0 8.311e-18
Ccc_CTAT_T1 CTAT xtemp__T1 8.311e-18
Ccc_CTAT_T2 CTAT xtemp__T2 8.311e-18
Ccc_CTAT_T3 CTAT xtemp__T3 8.311e-18
Ccc_CTAT_T4 CTAT xtemp__T4 8.311e-18
Ccc_CTAT_T5 CTAT xtemp__T5 8.311e-18
Ccc_CTAT_VDD CTAT VDD 9.7654e-17
Ccc_EN_RESETn_IBIAS RESETn IBIAS 3.4283e-17
Ccc_EN_RESETn_VDD RESETn VDD 1.2051e-16
Ccc_EN_RESETn_VREF RESETn VREF 2.2855e-17
Ccc_EN_RESETn_VSS RESETn VSS 7.0903e-17
Ccc_ENB_VDD xtemp__ENB VDD 7.4799e-17
Ccc_IBIAS_POR_RAW IBIAS POR_RAW 2.2855e-17
Ccc_IBIAS_VDD IBIAS VDD 5.9216e-17
Ccc_IBIAS_VREF IBIAS VREF 1.1428e-17
Ccc_IBIAS_VSS IBIAS VSS 4.5711e-17
Ccc_M1D_NT xtemp__M1D xtemp__NT 8.311e-18
Ccc_M1D_VDD xtemp__M1D VDD 1.6622e-17
Ccc_M2D_NT xtemp__M2D xtemp__NT 8.311e-18
Ccc_M2D_VDD xtemp__M2D VDD 1.6622e-17
Ccc_M3D_NT xtemp__M3D xtemp__NT 8.311e-18
Ccc_M3D_VDD xtemp__M3D VDD 1.6622e-17
Ccc_N1_NT xtemp__N1 xtemp__NT 8.311e-18
Ccc_N1_VDD xtemp__N1 VDD 8.311e-18
Ccc_N2_NA xtemp__N2 xtemp__NA 8.311e-18
Ccc_N2_NB xtemp__N2 xtemp__NB 8.311e-18
Ccc_N2_NC xtemp__N2 xtemp__NC 8.311e-18
Ccc_N2_NT xtemp__N2 xtemp__NT 8.311e-18
Ccc_N2_PTAT xtemp__N2 PTAT 8.311e-18
Ccc_N2_T0 xtemp__N2 xtemp__T0 8.311e-18
Ccc_N2_T1 xtemp__N2 xtemp__T1 8.311e-18
Ccc_N2_T2 xtemp__N2 xtemp__T2 8.311e-18
Ccc_N2_T3 xtemp__N2 xtemp__T3 8.311e-18
Ccc_N2_T4 xtemp__N2 xtemp__T4 8.311e-18
Ccc_N2_T5 xtemp__N2 xtemp__T5 8.311e-18
Ccc_N2_VDD xtemp__N2 VDD 7.4799e-17
Ccc_NA_NC xtemp__NA xtemp__NC 1.6622e-17
Ccc_NA_NT xtemp__NA xtemp__NT 8.311e-18
Ccc_NA_NZ xtemp__NA xtemp__NZ 8.311e-18
Ccc_NA_PTAT xtemp__NA PTAT 8.311e-18
Ccc_NA_T0 xtemp__NA xtemp__T0 8.311e-18
Ccc_NA_T1 xtemp__NA xtemp__T1 8.311e-18
Ccc_NA_T2 xtemp__NA xtemp__T2 8.311e-18
Ccc_NA_T3 xtemp__NA xtemp__T3 8.311e-18
Ccc_NA_T4 xtemp__NA xtemp__T4 8.311e-18
Ccc_NA_T5 xtemp__NA xtemp__T5 8.311e-18
Ccc_NA_VDD xtemp__NA VDD 7.4799e-17
Ccc_NA_VSS xtemp__NA VSS 1.32976e-16
Ccc_NB_NC xtemp__NB xtemp__NC 8.311e-18
Ccc_NB_NT xtemp__NB xtemp__NT 8.311e-18
Ccc_NB_NZ xtemp__NB xtemp__NZ 8.311e-18
Ccc_NB_PTAT xtemp__NB PTAT 8.311e-18
Ccc_NB_T0 xtemp__NB xtemp__T0 8.311e-18
Ccc_NB_T1 xtemp__NB xtemp__T1 8.311e-18
Ccc_NB_T2 xtemp__NB xtemp__T2 8.311e-18
Ccc_NB_T3 xtemp__NB xtemp__T3 8.311e-18
Ccc_NB_T4 xtemp__NB xtemp__T4 8.311e-18
Ccc_NB_T5 xtemp__NB xtemp__T5 8.311e-18
Ccc_NB_VDD xtemp__NB VDD 7.4799e-17
Ccc_NBG_VDD xtemp__NBG VDD 3.3244e-17
Ccc_NC_NT xtemp__NC xtemp__NT 8.311e-18
Ccc_NC_NZ xtemp__NC xtemp__NZ 8.311e-18
Ccc_NC_PTAT xtemp__NC PTAT 8.311e-18
Ccc_NC_T0 xtemp__NC xtemp__T0 1.6622e-17
Ccc_NC_T1 xtemp__NC xtemp__T1 1.6622e-17
Ccc_NC_T2 xtemp__NC xtemp__T2 1.6622e-17
Ccc_NC_T3 xtemp__NC xtemp__T3 1.6622e-17
Ccc_NC_T4 xtemp__NC xtemp__T4 1.6622e-17
Ccc_NC_T5 xtemp__NC xtemp__T5 1.6622e-17
Ccc_NC_VDD xtemp__NC VDD 7.4799e-17
Ccc_NC_VSS xtemp__NC VSS 2.65952e-16
Ccc_ND_NT xtemp__ND xtemp__NT 8.311e-18
Ccc_ND_VDD xtemp__ND VDD 6.6488e-17
Ccc_NR_NT xtemp__NR xtemp__NT 8.311e-18
Ccc_NR_VDD xtemp__NR VDD 6.6488e-17
Ccc_NT_NZ xtemp__NT xtemp__NZ 8.311e-18
Ccc_NT_PG xtemp__NT xtemp__PG 8.311e-18
Ccc_NT_PTAT xtemp__NT PTAT 8.311e-18
Ccc_NT_T0 xtemp__NT xtemp__T0 8.311e-18
Ccc_NT_T1 xtemp__NT xtemp__T1 8.311e-18
Ccc_NT_T2 xtemp__NT xtemp__T2 8.311e-18
Ccc_NT_T3 xtemp__NT xtemp__T3 8.311e-18
Ccc_NT_T4 xtemp__NT xtemp__T4 8.311e-18
Ccc_NT_T5 xtemp__NT xtemp__T5 8.311e-18
Ccc_NT_VDD xtemp__NT VDD 7.4799e-17
Ccc_NZ_PG xtemp__NZ xtemp__PG 1.36745e-16
Ccc_NZ_VDD xtemp__NZ VDD 7.4799e-17
Ccc_PB_VDD xtemp__PB VDD 5.8177e-17
Ccc_PCAS_VDD xtemp__PCAS VDD 4.1555e-17
Ccc_PG_VDD xtemp__PG VDD 7.4799e-17
Ccc_POR_RAW_VDD POR_RAW VDD 1.1428e-17
Ccc_POR_RAW_VREF POR_RAW VREF 1.1428e-17
Ccc_POR_RAW_VSS POR_RAW VSS 2.2855e-17
Ccc_PTAT_T0 PTAT xtemp__T0 8.311e-18
Ccc_PTAT_T1 PTAT xtemp__T1 8.311e-18
Ccc_PTAT_T2 PTAT xtemp__T2 8.311e-18
Ccc_PTAT_T3 PTAT xtemp__T3 8.311e-18
Ccc_PTAT_T4 PTAT xtemp__T4 8.311e-18
Ccc_PTAT_T5 PTAT xtemp__T5 8.311e-18
Ccc_PTAT_VDD PTAT VDD 9.7654e-17
Ccc_T0_T1 xtemp__T0 xtemp__T1 1.6622e-17
Ccc_T0_T2 xtemp__T0 xtemp__T2 1.6622e-17
Ccc_T0_T3 xtemp__T0 xtemp__T3 1.6622e-17
Ccc_T0_T4 xtemp__T0 xtemp__T4 1.6622e-17
Ccc_T0_T5 xtemp__T0 xtemp__T5 1.6622e-17
Ccc_T0_VDD xtemp__T0 VDD 7.4799e-17
Ccc_T1_T2 xtemp__T1 xtemp__T2 1.6622e-17
Ccc_T1_T3 xtemp__T1 xtemp__T3 1.6622e-17
Ccc_T1_T4 xtemp__T1 xtemp__T4 1.6622e-17
Ccc_T1_T5 xtemp__T1 xtemp__T5 1.6622e-17
Ccc_T1_VDD xtemp__T1 VDD 7.4799e-17
Ccc_T2_T3 xtemp__T2 xtemp__T3 1.6622e-17
Ccc_T2_T4 xtemp__T2 xtemp__T4 1.6622e-17
Ccc_T2_T5 xtemp__T2 xtemp__T5 1.6622e-17
Ccc_T2_VDD xtemp__T2 VDD 7.4799e-17
Ccc_T3_T4 xtemp__T3 xtemp__T4 1.6622e-17
Ccc_T3_T5 xtemp__T3 xtemp__T5 1.6622e-17
Ccc_T3_VDD xtemp__T3 VDD 7.4799e-17
Ccc_T4_T5 xtemp__T4 xtemp__T5 1.6622e-17
Ccc_T4_VDD xtemp__T4 VDD 7.4799e-17
Ccc_T5_VDD xtemp__T5 VDD 7.4799e-17
Ccc_VDD_VREF VDD VREF 1.1428e-17
Ccc_VDD_VSS VDD VSS 9.1421e-17
Ccc_VREF_VSS VREF VSS 2.2855e-17
Rvsubs_dctie VSS 0 1e+12
.ends temp_por_top
