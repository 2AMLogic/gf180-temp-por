* temp_core -- klt lvs reference netlist
* generated by layout/lvs_reference.py from design/netlist/temp_core.spice
* Do not edit: edit the schematic, re-run design/netlist.py, re-run this.
.SUBCKT temp_core VSS VDD EN ENB IBIAS NBG PB PCAS NT NA NB N1 N2 PG M1D M2D M3D ND NR CTAT PTAT T5 T4 T3 T2 T1 T0 NC NZ vsubs
M1 IBIAS NBG VSS vsubs nfet L=2U W=4U
M2 IBIAS EN NBG vsubs nfet L=0.5U W=2U
M3 NBG ENB VSS vsubs nfet L=0.5U W=2U
M4 PB NBG VSS vsubs nfet L=2U W=4U
M5 PB PB VDD NW1 pfet L=4U W=10U
M6 PCAS NBG VSS vsubs nfet L=2U W=4U
M7 PCAS PCAS VDD NW1 pfet L=8U W=1U
M8 ENB EN VDD NW1 pfet L=0.5U W=2U
M9 ENB EN VSS vsubs nfet L=0.5U W=1U
M10 NT PB VDD NW1 pfet L=4U W=20U
M11 N1 NA NT NW2 pfet L=4U W=16U
M12 N1 NA NT NW2 pfet L=4U W=16U
M13 N2 NB NT NW2 pfet L=4U W=16U
M14 N2 NB NT NW2 pfet L=4U W=16U
M15 N1 N1 VSS vsubs nfet L=8U W=4U
M16 N1 N1 VSS vsubs nfet L=8U W=4U
M17 N2 N1 VSS vsubs nfet L=8U W=4U
M18 N2 N1 VSS vsubs nfet L=8U W=4U
M19 PG N2 VSS vsubs nfet L=8U W=8U
M20 PG PB VDD NW1 pfet L=4U W=10U
M21 M1D PG VDD NW1 pfet L=4U W=4U
M22 M1D PG VDD NW1 pfet L=4U W=4U
M23 NA PCAS M1D NW1 pfet L=1U W=4U
M24 NA PCAS M1D NW1 pfet L=1U W=4U
M25 M2D PG VDD NW1 pfet L=4U W=4U
M26 M2D PG VDD NW1 pfet L=4U W=4U
M27 NB PCAS M2D NW1 pfet L=1U W=4U
M28 NB PCAS M2D NW1 pfet L=1U W=4U
M29 M3D PG VDD NW1 pfet L=4U W=4U
M30 M3D PG VDD NW1 pfet L=4U W=4U
M31 PTAT PCAS M3D NW1 pfet L=1U W=4U
M32 PTAT PCAS M3D NW1 pfet L=1U W=4U
M33 ND PB VDD NW1 pfet L=8U W=1U
M34 ND NR VSS vsubs nfet L=2U W=2U
M35 PG ND VSS vsubs nfet L=1U W=4U
M36 ND ENB VSS vsubs nfet L=0.5U W=2U
M37 PG EN VDD NW1 pfet L=0.5U W=4U
M38 PTAT ENB VSS vsubs nfet L=1U W=1U
M39 CTAT ENB VSS vsubs nfet L=1U W=1U
M40 NR PG VDD NW1 pfet L=4U W=1U
M41 NR NR VSS vsubs nfet L=2U W=2U
M42 N2 ENB VSS vsubs nfet L=1U W=2U
M43 NT ENB VSS vsubs nfet L=1U W=2U
M44 T5 VDD T4 vsubs nfet L=0.5U W=32U
M45 T4 VSS T3 vsubs nfet L=0.5U W=32U
M46 T3 VSS T2 vsubs nfet L=0.5U W=32U
M47 T2 VSS T1 vsubs nfet L=0.5U W=32U
M48 T1 VSS T0 vsubs nfet L=0.5U W=32U
M49 T0 VSS VSS vsubs nfet L=0.5U W=32U
MD50 NT NT NT NW2 pfet L=4U W=16U
MD51 NT NT NT NW2 pfet L=4U W=16U
MD52 VSS VSS VSS vsubs nfet L=8U W=4U
MD53 VSS VSS VSS vsubs nfet L=8U W=4U
MD54 VDD VDD VDD NW1 pfet L=4U W=4U
MD55 VDD VDD VDD NW1 pfet L=4U W=4U
R56 NB XR1.1 vsubs 10453.625 ppolyf_u
R57 XR1.1 NC vsubs 10453.625 ppolyf_u
R58 NA XRISO.1 vsubs 9716.875 ppolyf_u
R59 XRISO.1 CTAT vsubs 9716.875 ppolyf_u
R60 NZ XRZ.1 vsubs 17500 ppolyf_u
R61 XRZ.1 XRZ.2 vsubs 17500 ppolyf_u
R62 XRZ.2 XRZ.3 vsubs 17500 ppolyf_u
R63 XRZ.3 XRZ.4 vsubs 17500 ppolyf_u
R64 XRZ.4 XRZ.5 vsubs 17500 ppolyf_u
R65 XRZ.5 XRZ.6 vsubs 17500 ppolyf_u
R66 XRZ.6 XRZ.7 vsubs 17500 ppolyf_u
R67 XRZ.7 XRZ.8 vsubs 17500 ppolyf_u
R68 XRZ.8 XRZ.9 vsubs 17500 ppolyf_u
R69 XRZ.9 N2 vsubs 17500 ppolyf_u
R70 PTAT XR2F.1 vsubs 19341.875 ppolyf_u
R71 XR2F.1 XR2F.2 vsubs 19341.875 ppolyf_u
R72 XR2F.2 XR2F.3 vsubs 19341.875 ppolyf_u
R73 XR2F.3 XR2F.4 vsubs 19341.875 ppolyf_u
R74 XR2F.4 XR2F.5 vsubs 19341.875 ppolyf_u
R75 XR2F.5 XR2F.6 vsubs 19341.875 ppolyf_u
R76 XR2F.6 XR2F.7 vsubs 19341.875 ppolyf_u
R77 XR2F.7 XR2F.8 vsubs 19341.875 ppolyf_u
R78 XR2F.8 XR2F.9 vsubs 19341.875 ppolyf_u
R79 XR2F.9 XR2F.10 vsubs 19341.875 ppolyf_u
R80 XR2F.10 XR2F.11 vsubs 19341.875 ppolyf_u
R81 XR2F.11 XR2F.12 vsubs 19341.875 ppolyf_u
R82 XR2F.12 XR2F.13 vsubs 19341.875 ppolyf_u
R83 XR2F.13 XR2F.14 vsubs 19341.875 ppolyf_u
R84 XR2F.14 XR2F.15 vsubs 19341.875 ppolyf_u
R85 XR2F.15 XR2F.16 vsubs 19341.875 ppolyf_u
R86 XR2F.16 XR2F.17 vsubs 19341.875 ppolyf_u
R87 XR2F.17 XR2F.18 vsubs 19341.875 ppolyf_u
R88 XR2F.18 XR2F.19 vsubs 19341.875 ppolyf_u
R89 XR2F.19 XR2F.20 vsubs 19341.875 ppolyf_u
R90 XR2F.20 XR2F.21 vsubs 19341.875 ppolyf_u
R91 XR2F.21 XR2F.22 vsubs 19341.875 ppolyf_u
R92 XR2F.22 XR2F.23 vsubs 19341.875 ppolyf_u
R93 XR2F.23 T5 vsubs 19341.875 ppolyf_u
R94 T5 XR2T5.1 vsubs 20099.625 ppolyf_u
R95 XR2T5.1 T4 vsubs 20099.625 ppolyf_u
R96 T4 XR2T4.1 vsubs 10035.375 ppolyf_u
R97 XR2T4.1 T3 vsubs 10035.375 ppolyf_u
R98 T3 XR2T3.1 vsubs 5003.25 ppolyf_u
R99 XR2T3.1 T2 vsubs 5003.25 ppolyf_u
R100 T2 XR2T2.1 vsubs 2486.75 ppolyf_u
R101 XR2T2.1 T1 vsubs 2486.75 ppolyf_u
R102 T1 XR2T1.1 vsubs 1227.625 ppolyf_u
R103 XR2T1.1 T0 vsubs 1227.625 ppolyf_u
R104 T0 XR2T0.1 vsubs 599.375 ppolyf_u
R105 XR2T0.1 VSS vsubs 599.375 ppolyf_u
Q106 vsubs NWQ NA bjt AE=100P
Q107 vsubs NWQ NC bjt AE=100P
Q108 vsubs NWQ NC bjt AE=100P
Q109 vsubs NWQ NC bjt AE=100P
Q110 vsubs NWQ NC bjt AE=100P
Q111 vsubs NWQ NC bjt AE=100P
Q112 vsubs NWQ NC bjt AE=100P
Q113 vsubs NWQ NC bjt AE=100P
Q114 vsubs NWQ NC bjt AE=100P
C115 PG NZ 2.88e-13 cap_mim_2f0_m4m5_noshield
.ENDS temp_core
