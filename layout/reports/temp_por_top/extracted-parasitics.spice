* extracted by klt extract --deck gf180mcu
* parasitic model (--parasitics):
* - capacitance: net-to-ground for every net's own (non-coupled) area/perimeter, plus net-to-net for the vertical-overlap coupling `coupling` describes below -- a coupled net pair gets a direct capacitor between their two hub nodes, not just capacitors to the deck's ground/substrate net
* - coupling: vertical overlap (crossover) unconditionally -- where one net's conductor on an adjacent metal level sits directly over another *distinct* net's conductor, that overlap area is charged between the two nets instead of to ground (issue #760) -- plus lateral (same-layer, sidewall) coupling, but only for a net pair naming one of the caller's declared `--critical-net` nets (issue #976): facing-edge length within that layer's own minimum-spacing lookback is charged between the two nets, *additively* (not deducted from either net's substrate fringe term, unlike the vertical case -- a known simplification). Any same-layer pair with neither side named `--critical-net`, and fringe shielding in general, are still not modelled
* - resistance: single lumped series resistance per net, distributed as a star across that net's device terminals (issue #592) -- not a per-segment, distributed RC ladder, *unless* `--distributed-rc` names this net via `--critical-net` (issue #977, Epic #709 Phase 2b): then the net's terminals are ordered along their approximate physical spread and its total R/C is broken into a chain of per-segment resistors (segment length proportional to inter-terminal distance) with a ground capacitor at each terminal node (proportional to its adjacent segment length/2), instead of one star hub -- still an approximation (terminal position is a device-placement proxy, not true per-segment routing geometry), but a strictly finer-grained one than the single-hub star
* - frequency: quasi-static -- one frequency-independent R and C per net; no skin effect, no distributed transmission-line behavior
.GLOBAL vsubs

* cell temp_por_top
* pin CTAT
* pin EN,RESETn
* pin PTAT
* pin VDD
* pin VSS
.SUBCKT temp_por_top CTAT EN|RESETn PTAT VDD VSS
* device instance $1 r0 *1 112.4,-399 nfet
M$1 \$8__t3 \$8__t2 VSS__t1 VSS__t186 nfet L=4U W=2U AS=1.6P AD=1.6P PS=5.6U
+ PD=5.6U
* device instance $2 r0 *1 119,-399 nfet
M$2 \$9__t2 \$8__t1 VSS__t85 VSS__t187 nfet L=4U W=2U AS=1.6P AD=1.6P PS=5.6U
+ PD=5.6U
* device instance $3 r0 *1 127.6,-398 nfet
M$3 \$12__t3 \$12__t1 VSS__t2 VSS__t192 nfet L=8U W=4U AS=3.2P AD=3.2P PS=9.6U
+ PD=9.6U
* device instance $4 r0 *1 138.2,-398 nfet
M$4 \$13__t0 \$12__t2 VSS__t78 VSS__t193 nfet L=8U W=4U AS=3.2P AD=3.2P PS=9.6U
+ PD=9.6U
* device instance $5 r0 *1 148.8,-396 nfet
M$5 \$6__t2 \$13__t1 VSS__t3 VSS__t200 nfet L=8U W=8U AS=6.4P AD=6.4P PS=17.6U
+ PD=17.6U
* device instance $6 r0 *1 159.4,-399.5 nfet
M$6 VDD__t10 VDD__t11 \$41__t0 VSS__t202 nfet L=8U W=1U AS=0.8P AD=0.8P PS=3.6U
+ PD=3.6U
* device instance $7 r0 *1 170,-399.5 nfet
M$7 \$41__t2 \$41__t1 \$42__t0 VSS__t203 nfet L=8U W=1U AS=0.8P AD=0.8P PS=3.6U
+ PD=3.6U
* device instance $8 r0 *1 180.6,-399.5 nfet
M$8 \$42__t2 \$42__t1 \$43__t0 VSS__t204 nfet L=8U W=1U AS=0.8P AD=0.8P PS=3.6U
+ PD=3.6U
* device instance $9 r0 *1 191.2,-399.5 nfet
M$9 \$43__t2 \$43__t1 \$44__t0 VSS__t205 nfet L=8U W=1U AS=0.8P AD=0.8P PS=3.6U
+ PD=3.6U
* device instance $10 r0 *1 201.8,-399.5 nfet
M$10 \$44__t2 \$44__t1 \$17__t3 VSS__t206 nfet L=8U W=1U AS=0.8P AD=0.8P
+ PS=3.6U PD=3.6U
* device instance $11 r0 *1 210.4,-399 nfet
M$11 \$39__t3 \$39__t1 VSS__t87 VSS__t188 nfet L=4U W=2U AS=1.6P AD=1.6P
+ PS=5.6U PD=5.6U
* device instance $12 r0 *1 217,-396 nfet
M$12 \$17__t0 \$39__t2 VSS__t4 VSS__t207 nfet L=4U W=8U AS=6.4P AD=6.4P
+ PS=17.6U PD=17.6U
* device instance $13 r0 *1 223.6,-399.5 nfet
M$13 \$6__t3 \$17__t1 VSS__t5 VSS__t208 nfet L=4U W=1U AS=0.8P AD=0.8P PS=3.6U
+ PD=3.6U
* device instance $14 r0 *1 230.2,-399 nfet
M$14 \$16__t2 \$16__t0 VSS__t86 VSS__t189 nfet L=4U W=2U AS=1.6P AD=1.6P
+ PS=5.6U PD=5.6U
* device instance $15 r0 *1 236.8,-399 nfet
M$15 \$15__t2 \$16__t1 VSS__t88 VSS__t190 nfet L=4U W=2U AS=1.6P AD=1.6P
+ PS=5.6U PD=5.6U
* device instance $16 r0 *1 241.9,-399 nfet
M$16 \$15__t0 \$17__t2 VSS__t6 VSS__t209 nfet L=1U W=2U AS=1.6P AD=1.6P PS=5.6U
+ PD=5.6U
* device instance $17 r0 *1 247,-399 nfet
M$17 \$40__t2 \$15__t1 VSS__t89 VSS__t191 nfet L=4U W=2U AS=1.6P AD=1.6P
+ PS=5.6U PD=5.6U
* device instance $18 r0 *1 251.85,-398 nfet
M$18 BIAS_OK__t0 \$40__t0 VSS__t7 VSS__t215 nfet L=0.5U W=4U AS=3.2P AD=3.2P
+ PS=9.6U PD=9.6U
* device instance $19 r0 *1 471.8,-399 nfet
M$19 \$20__t3 \$25__t2 \$24__t1 VSS__t210 nfet L=1U W=2U AS=1.6P AD=1.6P
+ PS=5.6U PD=5.6U
* device instance $20 r0 *1 475.4,-399 nfet
M$20 \$21__t4 VREF__t1 \$24__t2 VSS__t211 nfet L=1U W=2U AS=1.6P AD=1.6P
+ PS=5.6U PD=5.6U
* device instance $21 r0 *1 483.5,-399.5 nfet
M$21 \$24__t0 \$26__t0 VSS__t8 VSS__t216 nfet L=10U W=1U AS=0.8P AD=0.8P
+ PS=3.6U PD=3.6U
* device instance $22 r0 *1 492.1,-399 nfet
M$22 IBIAS__t1 \$26__t1 VSS__t9 VSS__t217 nfet L=2U W=2U AS=1.6P AD=1.6P
+ PS=5.6U PD=5.6U
* device instance $23 r0 *1 495.95,-399 nfet
M$23 IBIAS__t8 BIAS_OK__t3 \$26__t3 VSS__t220 nfet L=0.5U W=2U AS=1.6P AD=1.6P
+ PS=5.6U PD=5.6U
* device instance $24 r0 *1 499.05,-399 nfet
M$24 \$26__t2 BIAS_OKB__t1 VSS__t10 VSS__t221 nfet L=0.5U W=2U AS=1.6P AD=1.6P
+ PS=5.6U PD=5.6U
* device instance $25 r0 *1 502.4,-399.5 nfet
M$25 IBIAS__t2 BIAS_OKB__t2 VSS__t11 VSS__t228 nfet L=1U W=1U AS=0.8P AD=0.8P
+ PS=3.6U PD=3.6U
* device instance $26 r0 *1 505.75,-395 nfet
M$26 \$27__t1 \$23__t1 VSS__t12 VSS__t234 nfet L=0.5U W=10U AS=8P AD=8P
+ PS=21.6U PD=21.6U
* device instance $27 r0 *1 509.1,-399 nfet
M$27 \$21__t3 BIAS_OKB__t5 VSS__t76 VSS__t212 nfet L=1U W=2U AS=1.6P AD=1.6P
+ PS=5.6U PD=5.6U
* device instance $28 r0 *1 512.45,-399.5 nfet
M$28 \$23__t2 \$21__t1 VSS__t13 VSS__t236 nfet L=0.5U W=1U AS=0.8P AD=0.8P
+ PS=3.6U PD=3.6U
* device instance $29 r0 *1 515.55,-399.5 nfet
M$29 POR_RAW__t1 \$23__t3 VSS__t56 VSS__t237 nfet L=0.5U W=1U AS=0.8P AD=0.8P
+ PS=3.6U PD=3.6U
* device instance $30 r0 *1 523.35,-399.5 nfet
M$30 BIAS_OKB__t3 BIAS_OK__t1 VSS__t14 VSS__t240 nfet L=0.5U W=1U AS=0.5P
+ AD=0.8P PS=3U PD=3.6U
* device instance $31 r0 *1 922.8,-398 nfet
M$31 IBIAS__t3 IBIAS__t4 VSS__t15 VSS__t241 nfet L=4U W=4U AS=3.2P AD=3.2P
+ PS=9.6U PD=9.6U
* device instance $32 r0 *1 939.9,-399.75 nfet
M$32 \$28__t0 IBIAS__t5 VSS__t16 VSS__t242 nfet L=25U W=0.5U AS=0.4P AD=0.4P
+ PS=2.6U PD=2.6U
* device instance $33 r0 *1 960,-399 nfet
M$33 \$29__t0 \$29__t1 VSS__t17 VSS__t243 nfet L=10U W=2U AS=1.6P AD=1.6P
+ PS=5.6U PD=5.6U
* device instance $34 r0 *1 972.6,-395 nfet
M$34 \$30__t0 \$29__t2 VSS__t18 VSS__t244 nfet L=10U W=10U AS=8P AD=8P PS=21.6U
+ PD=21.6U
* device instance $35 r0 *1 980.45,-399.5 nfet
M$35 \$47__t3 POR_RAW__t2 \$30__t1 VSS__t238 nfet L=0.5U W=1U AS=0.8P AD=0.8P
+ PS=3.6U PD=3.6U
* device instance $36 r0 *1 983.55,-399 nfet
M$36 \$31__t3 \$47__t4 VSS__t66 VSS__t222 nfet L=0.5U W=2U AS=1.6P AD=1.6P
+ PS=5.6U PD=5.6U
* device instance $37 r0 *1 987.4,-399.75 nfet
M$37 \$32__t0 \$31__t0 VSS__t19 VSS__t245 nfet L=2U W=0.5U AS=0.4P AD=0.4P
+ PS=2.6U PD=2.6U
* device instance $38 r0 *1 991.5,-399.5 nfet
M$38 \$48__t6 \$32__t2 VSS__t62 VSS__t229 nfet L=1U W=1U AS=0.8P AD=0.8P
+ PS=3.6U PD=3.6U
* device instance $39 r0 *1 999.6,-399.75 nfet
M$39 \$33__t0 \$29__t3 VSS__t20 VSS__t246 nfet L=10U W=0.5U AS=0.4P AD=0.4P
+ PS=2.6U PD=2.6U
* device instance $40 r0 *1 1007.7,-399.5 nfet
M$40 \$49__t1 \$33__t3 VSS__t59 VSS__t230 nfet L=1U W=1U AS=0.8P AD=0.8P
+ PS=3.6U PD=3.6U
* device instance $41 r0 *1 1011.3,-399.5 nfet
M$41 \$33__t2 EN|RESETn__t4 VSS__t61 VSS__t231 nfet L=1U W=1U AS=0.8P AD=0.8P
+ PS=3.6U PD=3.6U
* device instance $42 r0 *1 1014.65,-399 nfet
M$42 \$37__t3 \$49__t2 \$34__t1 VSS__t223 nfet L=0.5U W=2U AS=1.6P AD=1.6P
+ PS=5.6U PD=5.6U
* device instance $43 r0 *1 1017.75,-399 nfet
M$43 \$34__t0 \$31__t2 VSS__t64 VSS__t224 nfet L=0.5U W=2U AS=1.6P AD=1.6P
+ PS=5.6U PD=5.6U
* device instance $44 r0 *1 1132.25,-395 nfet
M$44 EN|RESETn__t3 \$37__t2 VSS__t58 VSS__t235 nfet L=0.5U W=10U AS=8P AD=8P
+ PS=21.6U PD=21.6U
* device instance $45 r0 *1 49.5,-2 nfet
M$45 VSS__t73 VSS__t71 VSS__t84 VSS__t194 nfet L=8U W=4U AS=3.2P AD=3.2P
+ PS=9.6U PD=9.6U
* device instance $46 r0 *1 59.6,-2 nfet
M$46 N1__t5 N1__t3 VSS__t83 VSS__t195 nfet L=8U W=4U AS=3.2P AD=3.2P PS=9.6U
+ PD=9.6U
* device instance $47 r0 *1 69.7,-2 nfet
M$47 N2__t4 N1__t2 VSS__t82 VSS__t196 nfet L=8U W=4U AS=3.2P AD=3.2P PS=9.6U
+ PD=9.6U
* device instance $48 r0 *1 79.8,-2 nfet
M$48 N2__t3 N1__t1 VSS__t81 VSS__t197 nfet L=8U W=4U AS=3.2P AD=3.2P PS=9.6U
+ PD=9.6U
* device instance $49 r0 *1 89.9,-2 nfet
M$49 N1__t4 N1__t0 VSS__t80 VSS__t198 nfet L=8U W=4U AS=3.2P AD=3.2P PS=9.6U
+ PD=9.6U
* device instance $50 r0 *1 100,-2 nfet
M$50 VSS__t72 VSS__t70 VSS__t79 VSS__t199 nfet L=8U W=4U AS=3.2P AD=3.2P
+ PS=9.6U PD=9.6U
* device instance $51 r0 *1 177.5,-4 nfet
M$51 PG__t10 N2__t2 VSS__t77 VSS__t201 nfet L=8U W=8U AS=6.4P AD=6.4P PS=17.6U
+ PD=17.6U
* device instance $52 r0 *1 190.7,-2 nfet
M$52 IBIAS__t6 NBG__t0 VSS__t21 VSS__t247 nfet L=2U W=4U AS=3.2P AD=3.2P
+ PS=9.6U PD=9.6U
* device instance $53 r0 *1 194.05,-1 nfet
M$53 IBIAS__t7 EN|RESETn__t5 NBG__t4 VSS__t225 nfet L=0.5U W=2U AS=1.6P AD=1.6P
+ PS=5.6U PD=5.6U
* device instance $54 r0 *1 196.65,-1 nfet
M$54 NBG__t3 ENB__t3 VSS__t65 VSS__t226 nfet L=0.5U W=2U AS=1.6P AD=1.6P
+ PS=5.6U PD=5.6U
* device instance $55 r0 *1 200,-2 nfet
M$55 PB__t5 NBG__t2 VSS__t55 VSS__t248 nfet L=2U W=4U AS=3.2P AD=3.2P PS=9.6U
+ PD=9.6U
* device instance $56 r0 *1 210.2,-2 nfet
M$56 PCAS__t0 NBG__t1 VSS__t54 VSS__t249 nfet L=2U W=4U AS=3.2P AD=3.2P PS=9.6U
+ PD=9.6U
* device instance $57 r0 *1 226.25,-0.5 nfet
M$57 ENB__t0 EN|RESETn__t2 VSS__t57 VSS__t239 nfet L=0.5U W=1U AS=0.8P AD=0.8P
+ PS=3.6U PD=3.6U
* device instance $58 r0 *1 239.7,-1 nfet
M$58 ND__t2 NR__t2 VSS__t69 VSS__t218 nfet L=2U W=2U AS=1.6P AD=1.6P PS=5.6U
+ PD=5.6U
* device instance $59 r0 *1 243.3,-2 nfet
M$59 PG__t0 ND__t0 VSS__t22 VSS__t250 nfet L=1U W=4U AS=3.2P AD=3.2P PS=9.6U
+ PD=9.6U
* device instance $60 r0 *1 253,-1 nfet
M$60 NR__t0 NR__t1 VSS__t68 VSS__t219 nfet L=2U W=2U AS=1.6P AD=1.6P PS=5.6U
+ PD=5.6U
* device instance $61 r0 *1 256.35,-1 nfet
M$61 ND__t3 ENB__t4 VSS__t67 VSS__t227 nfet L=0.5U W=2U AS=1.6P AD=1.6P PS=5.6U
+ PD=5.6U
* device instance $62 r0 *1 261.8,-0.5 nfet
M$62 PTAT__t1 ENB__t2 VSS__t63 VSS__t232 nfet L=1U W=1U AS=0.8P AD=0.8P PS=3.6U
+ PD=3.6U
* device instance $63 r0 *1 264.9,-0.5 nfet
M$63 CTAT__t1 ENB__t1 VSS__t60 VSS__t233 nfet L=1U W=1U AS=0.8P AD=0.8P PS=3.6U
+ PD=3.6U
* device instance $64 r0 *1 268,-1 nfet
M$64 N2__t1 ENB__t6 VSS__t74 VSS__t213 nfet L=1U W=2U AS=1.6P AD=1.6P PS=5.6U
+ PD=5.6U
* device instance $65 r0 *1 271.1,-1 nfet
M$65 NT__t1 ENB__t7 VSS__t75 VSS__t214 nfet L=1U W=2U AS=1.6P AD=1.6P PS=5.6U
+ PD=5.6U
* device instance $66 r0 *1 273.95,-16 nfet
M$66 T5__t0 VDD__t63 T4__t0 VSS__t251 nfet L=0.5U W=32U AS=25.6P AD=25.6P
+ PS=65.6U PD=65.6U
* device instance $67 r0 *1 276.55,-16 nfet
M$67 T3__t2 VSS__t24 T2__t3 VSS__t252 nfet L=0.5U W=32U AS=25.6P AD=25.6P
+ PS=65.6U PD=65.6U
* device instance $68 r0 *1 279.15,-16 nfet
M$68 T1__t2 VSS__t43 T0__t3 VSS__t253 nfet L=0.5U W=32U AS=25.6P AD=25.6P
+ PS=65.6U PD=65.6U
* device instance $69 r0 *1 281.75,-16 nfet
M$69 T0__t2 VSS__t44 VSS__t40 VSS__t254 nfet L=0.5U W=32U AS=25.6P AD=25.6P
+ PS=65.6U PD=65.6U
* device instance $70 r0 *1 284.35,-16 nfet
M$70 T2__t2 VSS__t41 T1__t3 VSS__t255 nfet L=0.5U W=32U AS=25.6P AD=25.6P
+ PS=65.6U PD=65.6U
* device instance $71 r0 *1 286.95,-16 nfet
M$71 T4__t3 VSS__t42 T3__t3 VSS__t256 nfet L=0.5U W=32U AS=25.6P AD=25.6P
+ PS=65.6U PD=65.6U
* device instance $72 r0 *1 2.8,-396 pfet
M$72 \$59__t0 \$6__t0 VDD__t1 VDD__t2 pfet L=4U W=8U AS=6.4P AD=6.4P PS=17.6U
+ PD=17.6U
* device instance $73 r0 *1 9.4,-396 pfet
M$73 \$7__t1 \$6__t6 VDD__t109 VDD__t106 pfet L=4U W=8U AS=6.4P AD=6.4P
+ PS=17.6U PD=17.6U
* device instance $74 r0 *1 16,-396 pfet
M$74 VREF__t2 \$6__t7 VDD__t110 VDD__t107 pfet L=4U W=8U AS=6.4P AD=6.4P
+ PS=17.6U PD=17.6U
* device instance $75 r0 *1 22.6,-399 pfet
M$75 \$8__t0 \$6__t1 VDD__t3 VDD__t4 pfet L=4U W=2U AS=1.6P AD=1.6P PS=5.6U
+ PD=5.6U
* device instance $76 r0 *1 29.2,-399 pfet
M$76 \$9__t5 \$9__t6 VDD__t102 VDD__t99 pfet L=4U W=2U AS=1.6P AD=1.6P PS=5.6U
+ PD=5.6U
* device instance $77 r0 *1 35.8,-380 pfet
M$77 IBIAS__t0 \$9__t0 VDD__t5 VDD__t6 pfet L=4U W=40U AS=32P AD=32P PS=81.6U
+ PD=81.6U
* device instance $78 r0 *1 42.4,-399 pfet
M$78 \$11__t2 \$9__t7 VDD__t103 VDD__t100 pfet L=4U W=2U AS=1.6P AD=1.6P
+ PS=5.6U PD=5.6U
* device instance $79 r0 *1 49,-392 pfet
M$79 \$12__t0 \$59__t1 \$11__t0 VDD__t7 pfet L=4U W=16U AS=12.8P AD=12.8P
+ PS=33.6U PD=33.6U
* device instance $80 r0 *1 55.6,-392 pfet
M$80 \$13__t3 \$18__t2 \$11__t1 VDD__t98 pfet L=4U W=16U AS=12.8P AD=12.8P
+ PS=33.6U PD=33.6U
* device instance $81 r0 *1 62.2,-399 pfet
M$81 \$6__t5 \$9__t8 VDD__t104 VDD__t101 pfet L=4U W=2U AS=1.6P AD=1.6P PS=5.6U
+ PD=5.6U
* device instance $82 r0 *1 68.8,-399.5 pfet
M$82 \$39__t0 \$9__t1 VDD__t8 VDD__t9 pfet L=4U W=1U AS=0.8P AD=0.8P PS=3.6U
+ PD=3.6U
* device instance $83 r0 *1 75.4,-399.5 pfet
M$83 \$14__t0 \$9__t3 VDD__t95 VDD__t91 pfet L=4U W=1U AS=0.8P AD=0.8P PS=3.6U
+ PD=3.6U
* device instance $84 r0 *1 82,-396 pfet
M$84 \$15__t3 \$59__t3 \$14__t1 VDD__t105 pfet L=4U W=8U AS=6.4P AD=6.4P
+ PS=17.6U PD=17.6U
* device instance $85 r0 *1 88.6,-396 pfet
M$85 \$16__t3 \$7__t2 \$14__t2 VDD__t108 pfet L=4U W=8U AS=6.4P AD=6.4P
+ PS=17.6U PD=17.6U
* device instance $86 r0 *1 95.2,-399.5 pfet
M$86 \$40__t3 \$9__t4 VDD__t96 VDD__t92 pfet L=4U W=1U AS=0.8P AD=0.8P PS=3.6U
+ PD=3.6U
* device instance $87 r0 *1 101.8,-399.5 pfet
M$87 BIAS_OK__t4 \$40__t4 VDD__t97 VDD__t93 pfet L=4U W=1U AS=0.8P AD=0.8P
+ PS=3.6U PD=3.6U
* device instance $88 r0 *1 451.3,-398 pfet
M$88 \$20__t0 \$20__t1 \$19__t0 VDD__t12 pfet L=1U W=4U AS=3.2P AD=3.2P PS=9.6U
+ PD=9.6U
* device instance $89 r0 *1 454.9,-398 pfet
M$89 \$21__t2 \$20__t2 \$19__t2 VDD__t86 pfet L=1U W=4U AS=3.2P AD=3.2P PS=9.6U
+ PD=9.6U
* device instance $90 r0 *1 458.25,-398 pfet
M$90 \$19__t1 BIAS_OKB__t0 VDD__t13 VDD__t14 pfet L=0.5U W=4U AS=3.2P AD=3.2P
+ PS=9.6U PD=9.6U
* device instance $91 r0 *1 461.35,-399 pfet
M$91 \$23__t0 \$21__t0 VDD__t15 VDD__t16 pfet L=0.5U W=2U AS=1.6P AD=1.6P
+ PS=5.6U PD=5.6U
* device instance $92 r0 *1 464.45,-399 pfet
M$92 POR_RAW__t3 \$23__t4 VDD__t75 VDD__t72 pfet L=0.5U W=2U AS=1.6P AD=1.6P
+ PS=5.6U PD=5.6U
* device instance $93 r0 *1 1029.6,-399 pfet
M$93 \$28__t1 \$28__t2 VDD__t17 VDD__t18 pfet L=10U W=2U AS=1.6P AD=1.6P
+ PS=5.6U PD=5.6U
* device instance $94 r0 *1 1042.2,-399 pfet
M$94 \$29__t4 \$28__t6 VDD__t70 VDD__t69 pfet L=10U W=2U AS=1.6P AD=1.6P
+ PS=5.6U PD=5.6U
* device instance $95 r0 *1 1054.8,-395 pfet
M$95 \$35__t0 \$28__t3 VDD__t19 VDD__t20 pfet L=10U W=10U AS=8P AD=8P PS=21.6U
+ PD=21.6U
* device instance $96 r0 *1 1067.4,-399.75 pfet
M$96 \$36__t0 \$28__t4 VDD__t21 VDD__t22 pfet L=10U W=0.5U AS=0.4P AD=0.4P
+ PS=2.6U PD=2.6U
* device instance $97 r0 *1 1080,-399.75 pfet
M$97 \$49__t0 \$28__t5 VDD__t67 VDD__t65 pfet L=10U W=0.5U AS=0.4P AD=0.4P
+ PS=2.6U PD=2.6U
* device instance $98 r0 *1 1087.85,-399.5 pfet
M$98 \$47__t0 POR_RAW__t0 \$35__t1 VDD__t23 pfet L=0.5U W=1U AS=0.8P AD=0.8P
+ PS=3.6U PD=3.6U
* device instance $99 r0 *1 1091.7,-399.75 pfet
M$99 \$31__t1 \$47__t1 VDD__t24 VDD__t25 pfet L=2U W=0.5U AS=0.4P AD=0.4P
+ PS=2.6U PD=2.6U
* device instance $100 r0 *1 1095.55,-399 pfet
M$100 \$32__t3 \$31__t5 VDD__t74 VDD__t71 pfet L=0.5U W=2U AS=1.6P AD=1.6P
+ PS=5.6U PD=5.6U
* device instance $101 r0 *1 1098.9,-399 pfet
M$101 \$48__t5 \$32__t1 \$36__t1 VDD__t26 pfet L=1U W=2U AS=1.6P AD=1.6P
+ PS=5.6U PD=5.6U
* device instance $102 r0 *1 1102.5,-399 pfet
M$102 \$33__t1 \$48__t0 VDD__t27 VDD__t64 pfet L=1U W=2U AS=1.6P AD=1.6P
+ PS=5.6U PD=5.6U
* device instance $103 r0 *1 1105.85,-398 pfet
M$103 \$37__t5 \$49__t3 VDD__t82 VDD__t79 pfet L=0.5U W=4U AS=3.2P AD=3.2P
+ PS=9.6U PD=9.6U
* device instance $104 r0 *1 1108.95,-398 pfet
M$104 \$37__t4 \$31__t4 VDD__t81 VDD__t78 pfet L=0.5U W=4U AS=3.2P AD=3.2P
+ PS=9.6U PD=9.6U
* device instance $105 r0 *1 1116.8,-399.75 pfet
M$105 \$37__t1 EN|RESETn__t1 VDD__t68 VDD__t66 pfet L=10U W=0.5U AS=0.4P
+ AD=0.4P PS=2.6U PD=2.6U
* device instance $106 r0 *1 1124.9,-399.5 pfet
M$106 EN|RESETn__t0 \$37__t0 VDD__t28 VDD__t29 pfet L=1U W=1U AS=0.8P AD=0.8P
+ PS=3.6U PD=3.6U
* device instance $107 r0 *1 2.8,42 pfet
M$107 NT__t2 NT__t4 NT__t9 NT__t15 pfet L=4U W=16U AS=12.8P AD=12.8P PS=33.6U
+ PD=33.6U
* device instance $108 r0 *1 8.9,42 pfet
M$108 N1__t6 NA__t4 NT__t8 NT__t14 pfet L=4U W=16U AS=12.8P AD=12.8P PS=33.6U
+ PD=33.6U
* device instance $109 r0 *1 15,42 pfet
M$109 N2__t6 NB__t4 NT__t7 NT__t13 pfet L=4U W=16U AS=12.8P AD=12.8P PS=33.6U
+ PD=33.6U
* device instance $110 r0 *1 21.1,42 pfet
M$110 N2__t5 NB__t3 NT__t6 NT__t12 pfet L=4U W=16U AS=12.8P AD=12.8P PS=33.6U
+ PD=33.6U
* device instance $111 r0 *1 27.2,42 pfet
M$111 N1__t7 NA__t5 NT__t10 NT__t16 pfet L=4U W=16U AS=12.8P AD=12.8P PS=33.6U
+ PD=33.6U
* device instance $112 r0 *1 33.3,42 pfet
M$112 NT__t3 NT__t5 NT__t11 NT__t17 pfet L=4U W=16U AS=12.8P AD=12.8P PS=33.6U
+ PD=33.6U
* device instance $113 r0 *1 41.4,44 pfet
M$113 NT__t0 PB__t0 VDD__t36 VDD__t33 pfet L=4U W=20U AS=16P AD=16P PS=41.6U
+ PD=41.6U
* device instance $114 r0 *1 108.1,36 pfet
M$114 VDD__t61 VDD__t59 VDD__t34 VDD__t35 pfet L=4U W=4U AS=3.2P AD=3.2P
+ PS=9.6U PD=9.6U
* device instance $115 r0 *1 114.2,36 pfet
M$115 M1D__t0 PG__t4 VDD__t52 VDD__t45 pfet L=4U W=4U AS=3.2P AD=3.2P PS=9.6U
+ PD=9.6U
* device instance $116 r0 *1 118.8,36 pfet
M$116 NA__t3 PCAS__t4 M1D__t3 VDD__t84 pfet L=1U W=4U AS=3.2P AD=3.2P PS=9.6U
+ PD=9.6U
* device instance $117 r0 *1 123.4,36 pfet
M$117 M2D__t0 PG__t5 VDD__t53 VDD__t46 pfet L=4U W=4U AS=3.2P AD=3.2P PS=9.6U
+ PD=9.6U
* device instance $118 r0 *1 128,36 pfet
M$118 NB__t1 PCAS__t6 M2D__t2 VDD__t87 pfet L=1U W=4U AS=3.2P AD=3.2P PS=9.6U
+ PD=9.6U
* device instance $119 r0 *1 132.6,36 pfet
M$119 M3D__t0 PG__t1 VDD__t54 VDD__t47 pfet L=4U W=4U AS=3.2P AD=3.2P PS=9.6U
+ PD=9.6U
* device instance $120 r0 *1 137.2,36 pfet
M$120 PTAT__t2 PCAS__t5 M3D__t2 VDD__t85 pfet L=1U W=4U AS=3.2P AD=3.2P PS=9.6U
+ PD=9.6U
* device instance $121 r0 *1 140.3,36 pfet
M$121 PTAT__t3 PCAS__t8 M3D__t3 VDD__t89 pfet L=1U W=4U AS=3.2P AD=3.2P PS=9.6U
+ PD=9.6U
* device instance $122 r0 *1 144.9,36 pfet
M$122 M3D__t1 PG__t8 VDD__t58 VDD__t51 pfet L=4U W=4U AS=3.2P AD=3.2P PS=9.6U
+ PD=9.6U
* device instance $123 r0 *1 149.5,36 pfet
M$123 NB__t2 PCAS__t7 M2D__t3 VDD__t88 pfet L=1U W=4U AS=3.2P AD=3.2P PS=9.6U
+ PD=9.6U
* device instance $124 r0 *1 154.1,36 pfet
M$124 M2D__t1 PG__t7 VDD__t57 VDD__t50 pfet L=4U W=4U AS=3.2P AD=3.2P PS=9.6U
+ PD=9.6U
* device instance $125 r0 *1 158.7,36 pfet
M$125 NA__t2 PCAS__t3 M1D__t2 VDD__t83 pfet L=1U W=4U AS=3.2P AD=3.2P PS=9.6U
+ PD=9.6U
* device instance $126 r0 *1 163.3,36 pfet
M$126 M1D__t1 PG__t6 VDD__t55 VDD__t48 pfet L=4U W=4U AS=3.2P AD=3.2P PS=9.6U
+ PD=9.6U
* device instance $127 r0 *1 169.4,36 pfet
M$127 VDD__t62 VDD__t60 VDD__t56 VDD__t49 pfet L=4U W=4U AS=3.2P AD=3.2P
+ PS=9.6U PD=9.6U
* device instance $128 r0 *1 185.6,39 pfet
M$128 PG__t2 PB__t1 VDD__t37 VDD__t38 pfet L=4U W=10U AS=8P AD=8P PS=21.6U
+ PD=21.6U
* device instance $129 r0 *1 205.1,39 pfet
M$129 PB__t4 PB__t2 VDD__t44 VDD__t43 pfet L=4U W=10U AS=8P AD=8P PS=21.6U
+ PD=21.6U
* device instance $130 r0 *1 217.3,34.5 pfet
M$130 PCAS__t1 PCAS__t2 VDD__t39 VDD__t40 pfet L=8U W=1U AS=0.8P AD=0.8P
+ PS=3.6U PD=3.6U
* device instance $131 r0 *1 223.65,35 pfet
M$131 ENB__t5 EN|RESETn__t7 VDD__t76 VDD__t73 pfet L=0.5U W=2U AS=1.6P AD=1.6P
+ PS=5.6U PD=5.6U
* device instance $132 r0 *1 232.6,34.5 pfet
M$132 ND__t1 PB__t3 VDD__t42 VDD__t41 pfet L=8U W=1U AS=0.8P AD=0.8P PS=3.6U
+ PD=3.6U
* device instance $133 r0 *1 247.9,34.5 pfet
M$133 NR__t3 PG__t11 VDD__t94 VDD__t90 pfet L=4U W=1U AS=0.8P AD=0.8P PS=3.6U
+ PD=3.6U
* device instance $134 r0 *1 258.95,36 pfet
M$134 PG__t9 EN|RESETn__t6 VDD__t80 VDD__t77 pfet L=0.5U W=4U AS=3.2P AD=3.2P
+ PS=9.6U PD=9.6U
* device instance $135 r0 *1 523.35,-396 pfet
M$135 BIAS_OKB__t4 BIAS_OK__t2 VDD__t31 VDD__t32 pfet L=0.5U W=2U AS=1P AD=1.6P
+ PS=5U PD=5.6U
* device instance $136 r0 *1 278.9,-382 bjt
Q$136 VSS__t90 VSS__t50 \$46__t6 bjt AE=100P PE=40U AB=169P PB=52U AC=169P
+ PC=52U NE=1
* device instance $137 r0 *1 293.9,-382 bjt
Q$137 VSS__t91 VSS__t49 \$46__t5 bjt AE=100P PE=40U AB=169P PB=52U AC=169P
+ PC=52U NE=1
* device instance $138 r0 *1 308.9,-382 bjt
Q$138 VSS__t92 VSS__t48 \$46__t4 bjt AE=100P PE=40U AB=169P PB=52U AC=169P
+ PC=52U NE=1
* device instance $139 r0 *1 278.9,-367 bjt
Q$139 VSS__t93 VSS__t47 \$46__t3 bjt AE=100P PE=40U AB=169P PB=52U AC=169P
+ PC=52U NE=1
* device instance $140 r0 *1 293.9,-367 bjt
Q$140 VSS__t94 VSS__t46 \$59__t2 bjt AE=100P PE=40U AB=169P PB=52U AC=169P
+ PC=52U NE=1
* device instance $141 r0 *1 308.9,-367 bjt
Q$141 VSS__t95 VSS__t45 \$46__t2 bjt AE=100P PE=40U AB=169P PB=52U AC=169P
+ PC=52U NE=1
* device instance $142 r0 *1 323.9,-367 bjt
Q$142 VSS__t96 VSS__t53 \$60__t1 bjt AE=100P PE=40U AB=169P PB=52U AC=169P
+ PC=52U NE=1
* device instance $143 r0 *1 278.9,-352 bjt
Q$143 VSS__t97 VSS__t23 \$46__t0 bjt AE=100P PE=40U AB=169P PB=52U AC=169P
+ PC=52U NE=1
* device instance $144 r0 *1 293.9,-352 bjt
Q$144 VSS__t98 VSS__t52 \$46__t8 bjt AE=100P PE=40U AB=169P PB=52U AC=169P
+ PC=52U NE=1
* device instance $145 r0 *1 308.9,-352 bjt
Q$145 VSS__t99 VSS__t51 \$46__t7 bjt AE=100P PE=40U AB=169P PB=52U AC=169P
+ PC=52U NE=1
* device instance $146 r0 *1 505,81 bjt
Q$146 VSS__t100 VSS__t28 NC__t1 bjt AE=100P PE=40U AB=144P PB=48U AC=144P
+ PC=48U NE=1
* device instance $147 r0 *1 519,81 bjt
Q$147 VSS__t101 VSS__t29 NC__t2 bjt AE=100P PE=40U AB=144P PB=48U AC=144P
+ PC=48U NE=1
* device instance $148 r0 *1 533,81 bjt
Q$148 VSS__t102 VSS__t30 NC__t3 bjt AE=100P PE=40U AB=144P PB=48U AC=144P
+ PC=48U NE=1
* device instance $149 r0 *1 505,95 bjt
Q$149 VSS__t103 VSS__t31 NC__t4 bjt AE=100P PE=40U AB=144P PB=48U AC=144P
+ PC=48U NE=1
* device instance $150 r0 *1 519,95 bjt
Q$150 VSS__t104 VSS__t36 NA__t1 bjt AE=100P PE=40U AB=144P PB=48U AC=144P
+ PC=48U NE=1
* device instance $151 r0 *1 533,95 bjt
Q$151 VSS__t105 VSS__t35 NC__t8 bjt AE=100P PE=40U AB=144P PB=48U AC=144P
+ PC=48U NE=1
* device instance $152 r0 *1 505,109 bjt
Q$152 VSS__t106 VSS__t34 NC__t7 bjt AE=100P PE=40U AB=144P PB=48U AC=144P
+ PC=48U NE=1
* device instance $153 r0 *1 519,109 bjt
Q$153 VSS__t107 VSS__t33 NC__t6 bjt AE=100P PE=40U AB=144P PB=48U AC=144P
+ PC=48U NE=1
* device instance $154 r0 *1 533,109 bjt
Q$154 VSS__t108 VSS__t32 NC__t5 bjt AE=100P PE=40U AB=144P PB=48U AC=144P
+ PC=48U NE=1
* device instance $155 r0 *1 988.8,-362.3 cap_mim_2f0_m4m5_noshield
C$155 \$47__t2 VSS__t26 2.512752e-13
* device instance $156 r0 *1 935.7,-353.8 cap_mim_2f0_m4m5_noshield
C$156 \$48__t1 VSS__t25 1.5868496e-12
* device instance $157 r0 *1 966.5,-353.8 cap_mim_2f0_m4m5_noshield
C$157 \$48__t4 VSS__t39 1.5868496e-12
* device instance $158 r0 *1 292.4,-329.3 cap_mim_2f0_m4m5_noshield
C$158 VDD__t30 \$40__t1 7.73592e-14
* device instance $159 r0 *1 276.6,-322.3 cap_mim_2f0_m4m5_noshield
C$159 \$6__t4 \$45__t0 8.15064e-13
* device instance $160 r0 *1 935.7,-323 cap_mim_2f0_m4m5_noshield
C$160 \$48__t3 VSS__t38 1.5868496e-12
* device instance $161 r0 *1 966.5,-323 cap_mim_2f0_m4m5_noshield
C$161 \$48__t2 VSS__t37 1.5868496e-12
* device instance $162 r0 *1 206.7,68.7 cap_mim_2f0_m4m5_noshield
C$162 PG__t3 NZ__t1 2.979984e-13
* device instance $163 r0 *1 307,92.867 ppolyf_u
R$163 NB__t0 \$134__t0 VSS__t109 10453.625 ppolyf_u L=59.735U W=2U
* device instance $164 r0 *1 310,92.867 ppolyf_u
R$164 NC__t0 \$134__t1 VSS__t110 10453.625 ppolyf_u L=59.735U W=2U
* device instance $165 r0 *1 313,90.762 ppolyf_u
R$165 NA__t0 \$132__t0 VSS__t111 9716.875 ppolyf_u L=55.525U W=2U
* device instance $166 r0 *1 316,90.762 ppolyf_u
R$166 CTAT__t0 \$132__t1 VSS__t112 9716.875 ppolyf_u L=55.525U W=2U
* device instance $167 r0 *1 319,113 ppolyf_u
R$167 NZ__t0 \$135__t0 VSS__t113 17500 ppolyf_u L=100U W=2U
* device instance $168 r0 *1 322,113 ppolyf_u
R$168 \$95__t0 \$135__t1 VSS__t114 17500 ppolyf_u L=100U W=2U
* device instance $169 r0 *1 325,113 ppolyf_u
R$169 \$95__t1 \$136__t0 VSS__t115 17500 ppolyf_u L=100U W=2U
* device instance $170 r0 *1 328,113 ppolyf_u
R$170 \$96__t0 \$136__t1 VSS__t116 17500 ppolyf_u L=100U W=2U
* device instance $171 r0 *1 331,113 ppolyf_u
R$171 \$96__t1 \$137__t0 VSS__t117 17500 ppolyf_u L=100U W=2U
* device instance $172 r0 *1 334,113 ppolyf_u
R$172 \$97__t1 \$137__t1 VSS__t118 17500 ppolyf_u L=100U W=2U
* device instance $173 r0 *1 337,113 ppolyf_u
R$173 \$97__t0 \$138__t1 VSS__t119 17500 ppolyf_u L=100U W=2U
* device instance $174 r0 *1 340,113 ppolyf_u
R$174 \$98__t1 \$138__t0 VSS__t120 17500 ppolyf_u L=100U W=2U
* device instance $175 r0 *1 343,113 ppolyf_u
R$175 \$98__t0 \$139__t1 VSS__t121 17500 ppolyf_u L=100U W=2U
* device instance $176 r0 *1 346,113 ppolyf_u
R$176 N2__t0 \$139__t0 VSS__t122 17500 ppolyf_u L=100U W=2U
* device instance $177 r0 *1 349,118.262 ppolyf_u
R$177 PTAT__t0 \$140__t0 VSS__t123 19341.875 ppolyf_u L=110.525U W=2U
* device instance $178 r0 *1 352,118.262 ppolyf_u
R$178 \$99__t1 \$140__t1 VSS__t124 19341.875 ppolyf_u L=110.525U W=2U
* device instance $179 r0 *1 355,118.262 ppolyf_u
R$179 \$99__t0 \$141__t0 VSS__t125 19341.875 ppolyf_u L=110.525U W=2U
* device instance $180 r0 *1 358,118.262 ppolyf_u
R$180 \$100__t1 \$141__t1 VSS__t126 19341.875 ppolyf_u L=110.525U W=2U
* device instance $181 r0 *1 361,118.262 ppolyf_u
R$181 \$100__t0 \$142__t0 VSS__t127 19341.875 ppolyf_u L=110.525U W=2U
* device instance $182 r0 *1 364,118.262 ppolyf_u
R$182 \$101__t1 \$142__t1 VSS__t128 19341.875 ppolyf_u L=110.525U W=2U
* device instance $183 r0 *1 367,118.262 ppolyf_u
R$183 \$101__t0 \$143__t1 VSS__t129 19341.875 ppolyf_u L=110.525U W=2U
* device instance $184 r0 *1 370,118.262 ppolyf_u
R$184 \$102__t1 \$143__t0 VSS__t130 19341.875 ppolyf_u L=110.525U W=2U
* device instance $185 r0 *1 373,118.262 ppolyf_u
R$185 \$102__t0 \$144__t1 VSS__t131 19341.875 ppolyf_u L=110.525U W=2U
* device instance $186 r0 *1 376,118.262 ppolyf_u
R$186 \$103__t1 \$144__t0 VSS__t132 19341.875 ppolyf_u L=110.525U W=2U
* device instance $187 r0 *1 379,118.262 ppolyf_u
R$187 \$103__t0 \$145__t1 VSS__t133 19341.875 ppolyf_u L=110.525U W=2U
* device instance $188 r0 *1 382,118.262 ppolyf_u
R$188 \$104__t1 \$145__t0 VSS__t134 19341.875 ppolyf_u L=110.525U W=2U
* device instance $189 r0 *1 385,118.262 ppolyf_u
R$189 \$104__t0 \$146__t1 VSS__t135 19341.875 ppolyf_u L=110.525U W=2U
* device instance $190 r0 *1 388,118.262 ppolyf_u
R$190 \$105__t0 \$146__t0 VSS__t136 19341.875 ppolyf_u L=110.525U W=2U
* device instance $191 r0 *1 391,118.262 ppolyf_u
R$191 \$105__t1 \$147__t1 VSS__t137 19341.875 ppolyf_u L=110.525U W=2U
* device instance $192 r0 *1 394,118.262 ppolyf_u
R$192 \$106__t1 \$147__t0 VSS__t138 19341.875 ppolyf_u L=110.525U W=2U
* device instance $193 r0 *1 397,118.262 ppolyf_u
R$193 \$106__t0 \$148__t1 VSS__t139 19341.875 ppolyf_u L=110.525U W=2U
* device instance $194 r0 *1 400,118.262 ppolyf_u
R$194 \$107__t1 \$148__t0 VSS__t140 19341.875 ppolyf_u L=110.525U W=2U
* device instance $195 r0 *1 403,118.262 ppolyf_u
R$195 \$107__t0 \$149__t1 VSS__t141 19341.875 ppolyf_u L=110.525U W=2U
* device instance $196 r0 *1 406,118.262 ppolyf_u
R$196 \$108__t1 \$149__t0 VSS__t142 19341.875 ppolyf_u L=110.525U W=2U
* device instance $197 r0 *1 409,118.262 ppolyf_u
R$197 \$108__t0 \$150__t1 VSS__t143 19341.875 ppolyf_u L=110.525U W=2U
* device instance $198 r0 *1 412,118.262 ppolyf_u
R$198 \$109__t1 \$150__t0 VSS__t144 19341.875 ppolyf_u L=110.525U W=2U
* device instance $199 r0 *1 415,118.262 ppolyf_u
R$199 \$109__t0 \$151__t1 VSS__t145 19341.875 ppolyf_u L=110.525U W=2U
* device instance $200 r0 *1 418,118.262 ppolyf_u
R$200 T5__t2 \$151__t0 VSS__t146 19341.875 ppolyf_u L=110.525U W=2U
* device instance $201 r0 *1 421,120.427 ppolyf_u
R$201 T5__t1 \$152__t0 VSS__t147 20099.625 ppolyf_u L=114.855U W=2U
* device instance $202 r0 *1 424,120.427 ppolyf_u
R$202 T4__t2 \$152__t1 VSS__t148 20099.625 ppolyf_u L=114.855U W=2U
* device instance $203 r0 *1 427,91.672 ppolyf_u
R$203 T4__t1 \$133__t0 VSS__t149 10035.375 ppolyf_u L=57.345U W=2U
* device instance $204 r0 *1 430,91.672 ppolyf_u
R$204 T3__t1 \$133__t1 VSS__t150 10035.375 ppolyf_u L=57.345U W=2U
* device instance $205 r0 *1 433,77.295 ppolyf_u
R$205 T3__t0 \$124__t0 VSS__t151 5003.25 ppolyf_u L=28.59U W=2U
* device instance $206 r0 *1 436,77.295 ppolyf_u
R$206 T2__t1 \$124__t1 VSS__t152 5003.25 ppolyf_u L=28.59U W=2U
* device instance $207 r0 *1 439,70.105 ppolyf_u
R$207 T2__t0 \$120__t0 VSS__t153 2486.75 ppolyf_u L=14.21U W=2U
* device instance $208 r0 *1 442,70.105 ppolyf_u
R$208 T1__t1 \$120__t1 VSS__t154 2486.75 ppolyf_u L=14.21U W=2U
* device instance $209 r0 *1 445,66.507 ppolyf_u
R$209 T1__t0 \$116__t0 VSS__t155 1227.625 ppolyf_u L=7.015U W=2U
* device instance $210 r0 *1 448,66.507 ppolyf_u
R$210 T0__t1 \$116__t1 VSS__t156 1227.625 ppolyf_u L=7.015U W=2U
* device instance $211 r0 *1 451,64.712 ppolyf_u
R$211 T0__t0 \$115__t0 VSS__t157 599.375 ppolyf_u L=3.425U W=2U
* device instance $212 r0 *1 454,64.712 ppolyf_u
R$212 VSS__t27 \$115__t1 VSS__t158 599.375 ppolyf_u L=3.425U W=2U
* device instance $213 r0 *1 759,-331.96 ppolyf_u_1k
R$213 \$27__t0 \$25__t1 VSS__t159 3384615 ppolyf_u_1k L=6769.23U W=2U
* device instance $214 r0 *1 860,-381.13 ppolyf_u_1k
R$214 VSS__t0 \$27__t2 VSS__t160 387500 ppolyf_u_1k L=775U W=2U
* device instance $215 r0 *1 607,-326.55 ppolyf_u_1k
R$215 \$25__t0 VDD__t0 VSS__t161 3948720 ppolyf_u_1k L=7897.44U W=2U
* device instance $216 r0 *1 342.9,-258.75 ppolyf_u_1k
R$216 VREF__t0 \$71__t0 VSS__t162 128250 ppolyf_u_1k L=256.5U W=2U
* device instance $217 r0 *1 345.9,-258.75 ppolyf_u_1k
R$217 \$50__t1 \$71__t1 VSS__t163 128250 ppolyf_u_1k L=256.5U W=2U
* device instance $218 r0 *1 348.9,-258.75 ppolyf_u_1k
R$218 \$50__t0 \$70__t1 VSS__t170 128250 ppolyf_u_1k L=256.5U W=2U
* device instance $219 r0 *1 351.9,-258.75 ppolyf_u_1k
R$219 \$51__t0 \$70__t0 VSS__t164 128250 ppolyf_u_1k L=256.5U W=2U
* device instance $220 r0 *1 354.9,-258.75 ppolyf_u_1k
R$220 \$51__t1 \$69__t0 VSS__t171 128250 ppolyf_u_1k L=256.5U W=2U
* device instance $221 r0 *1 357.9,-258.75 ppolyf_u_1k
R$221 \$52__t0 \$69__t1 VSS__t165 128250 ppolyf_u_1k L=256.5U W=2U
* device instance $222 r0 *1 360.9,-258.75 ppolyf_u_1k
R$222 \$52__t1 \$68__t0 VSS__t172 128250 ppolyf_u_1k L=256.5U W=2U
* device instance $223 r0 *1 363.9,-258.75 ppolyf_u_1k
R$223 \$53__t0 \$68__t1 VSS__t166 128250 ppolyf_u_1k L=256.5U W=2U
* device instance $224 r0 *1 366.9,-258.75 ppolyf_u_1k
R$224 \$53__t1 \$67__t0 VSS__t173 128250 ppolyf_u_1k L=256.5U W=2U
* device instance $225 r0 *1 369.9,-258.75 ppolyf_u_1k
R$225 \$54__t0 \$67__t1 VSS__t167 128250 ppolyf_u_1k L=256.5U W=2U
* device instance $226 r0 *1 372.9,-258.75 ppolyf_u_1k
R$226 \$54__t1 \$66__t0 VSS__t174 128250 ppolyf_u_1k L=256.5U W=2U
* device instance $227 r0 *1 375.9,-258.75 ppolyf_u_1k
R$227 \$55__t0 \$66__t1 VSS__t168 128250 ppolyf_u_1k L=256.5U W=2U
* device instance $228 r0 *1 378.9,-258.75 ppolyf_u_1k
R$228 \$55__t1 \$65__t0 VSS__t175 128250 ppolyf_u_1k L=256.5U W=2U
* device instance $229 r0 *1 381.9,-258.75 ppolyf_u_1k
R$229 \$56__t0 \$65__t1 VSS__t169 128250 ppolyf_u_1k L=256.5U W=2U
* device instance $230 r0 *1 384.9,-258.75 ppolyf_u_1k
R$230 \$56__t1 \$64__t0 VSS__t176 128250 ppolyf_u_1k L=256.5U W=2U
* device instance $231 r0 *1 387.9,-258.75 ppolyf_u_1k
R$231 \$60__t0 \$64__t1 VSS__t177 128250 ppolyf_u_1k L=256.5U W=2U
* device instance $232 r0 *1 394.9,-260 ppolyf_u_1k
R$232 \$45__t1 \$61__t0 VSS__t178 127000 ppolyf_u_1k L=254U W=2U
* device instance $233 r0 *1 397.9,-260 ppolyf_u_1k
R$233 \$57__t1 \$61__t1 VSS__t179 127000 ppolyf_u_1k L=254U W=2U
* device instance $234 r0 *1 400.9,-260 ppolyf_u_1k
R$234 \$57__t0 \$62__t1 VSS__t180 127000 ppolyf_u_1k L=254U W=2U
* device instance $235 r0 *1 403.9,-260 ppolyf_u_1k
R$235 \$13__t2 \$62__t0 VSS__t181 127000 ppolyf_u_1k L=254U W=2U
* device instance $236 r0 *1 410.9,-299.5 ppolyf_u_1k
R$236 \$18__t0 \$63__t1 VSS__t182 87500 ppolyf_u_1k L=175U W=2U
* device instance $237 r0 *1 413.9,-299.5 ppolyf_u_1k
R$237 \$46__t1 \$63__t0 VSS__t183 87500 ppolyf_u_1k L=175U W=2U
* device instance $238 r0 *1 420.9,-382.625 ppolyf_u_1k
R$238 \$7__t0 \$58__t1 VSS__t184 4375 ppolyf_u_1k L=8.75U W=2U
* device instance $239 r0 *1 423.9,-382.625 ppolyf_u_1k
R$239 \$18__t1 \$58__t0 VSS__t185 4375 ppolyf_u_1k L=8.75U W=2U
* device instance _100_t0 r0 *1 0,0
R_100_t0 \$100__t0 \$100 25.28745
* device instance _100_t1 r0 *1 0,0
R_100_t1 \$100__t1 \$100 25.28745
* device instance _100 r0 *1 0,0
C_100 \$100 vsubs 1.599507e-15
* device instance _101_t0 r0 *1 0,0
R_101_t0 \$101__t0 \$101 25.28745
* device instance _101_t1 r0 *1 0,0
R_101_t1 \$101__t1 \$101 25.28745
* device instance _101 r0 *1 0,0
C_101 \$101 vsubs 1.599507e-15
* device instance _102_t0 r0 *1 0,0
R_102_t0 \$102__t0 \$102 25.28745
* device instance _102_t1 r0 *1 0,0
R_102_t1 \$102__t1 \$102 25.28745
* device instance _102 r0 *1 0,0
C_102 \$102 vsubs 1.599507e-15
* device instance _103_t0 r0 *1 0,0
R_103_t0 \$103__t0 \$103 25.28745
* device instance _103_t1 r0 *1 0,0
R_103_t1 \$103__t1 \$103 25.28745
* device instance _103 r0 *1 0,0
C_103 \$103 vsubs 1.599507e-15
* device instance _104_t0 r0 *1 0,0
R_104_t0 \$104__t0 \$104 25.28745
* device instance _104_t1 r0 *1 0,0
R_104_t1 \$104__t1 \$104 25.28745
* device instance _104 r0 *1 0,0
C_104 \$104 vsubs 1.599507e-15
* device instance _105_t0 r0 *1 0,0
R_105_t0 \$105__t0 \$105 25.28745
* device instance _105_t1 r0 *1 0,0
R_105_t1 \$105__t1 \$105 25.28745
* device instance _105 r0 *1 0,0
C_105 \$105 vsubs 1.599507e-15
* device instance _106_t0 r0 *1 0,0
R_106_t0 \$106__t0 \$106 25.28745
* device instance _106_t1 r0 *1 0,0
R_106_t1 \$106__t1 \$106 25.28745
* device instance _106 r0 *1 0,0
C_106 \$106 vsubs 1.599507e-15
* device instance _107_t0 r0 *1 0,0
R_107_t0 \$107__t0 \$107 25.28745
* device instance _107_t1 r0 *1 0,0
R_107_t1 \$107__t1 \$107 25.28745
* device instance _107 r0 *1 0,0
C_107 \$107 vsubs 1.599507e-15
* device instance _108_t0 r0 *1 0,0
R_108_t0 \$108__t0 \$108 25.28745
* device instance _108_t1 r0 *1 0,0
R_108_t1 \$108__t1 \$108 25.28745
* device instance _108 r0 *1 0,0
C_108 \$108 vsubs 1.599507e-15
* device instance _109_t0 r0 *1 0,0
R_109_t0 \$109__t0 \$109 25.28745
* device instance _109_t1 r0 *1 0,0
R_109_t1 \$109__t1 \$109 25.28745
* device instance _109 r0 *1 0,0
C_109 \$109 vsubs 1.599507e-15
* device instance _11_t0 r0 *1 0,0
R_11_t0 \$11__t0 \$11 627.59414468
* device instance _11_t1 r0 *1 0,0
R_11_t1 \$11__t1 \$11 1882.86781906
* device instance _11_t2 r0 *1 0,0
R_11_t2 \$11__t2 \$11 2174.12383626
* device instance _11 r0 *1 0,0
C_11 \$11 vsubs 4.9951788e-14
* device instance _115_t0 r0 *1 0,0
R_115_t0 \$115__t0 \$115 25.28745
* device instance _115_t1 r0 *1 0,0
R_115_t1 \$115__t1 \$115 25.28745
* device instance _115 r0 *1 0,0
C_115 \$115 vsubs 1.599507e-15
* device instance _116_t0 r0 *1 0,0
R_116_t0 \$116__t0 \$116 25.28745
* device instance _116_t1 r0 *1 0,0
R_116_t1 \$116__t1 \$116 25.28745
* device instance _116 r0 *1 0,0
C_116 \$116 vsubs 1.599507e-15
* device instance _12_t0 r0 *1 0,0
R_12_t0 \$12__t0 \$12 2483.75464397
* device instance _12_t1 r0 *1 0,0
R_12_t1 \$12__t1 \$12 686.286100229
* device instance _12_t2 r0 *1 0,0
R_12_t2 \$12__t2 \$12 1111.53145557
* device instance _12_t3 r0 *1 0,0
R_12_t3 \$12__t3 \$12 686.286100229
* device instance _12 r0 *1 0,0
C_12 \$12 vsubs 5.978126e-14
* device instance _120_t0 r0 *1 0,0
R_120_t0 \$120__t0 \$120 25.28745
* device instance _120_t1 r0 *1 0,0
R_120_t1 \$120__t1 \$120 25.28745
* device instance _120 r0 *1 0,0
C_120 \$120 vsubs 1.599507e-15
* device instance _124_t0 r0 *1 0,0
R_124_t0 \$124__t0 \$124 25.28745
* device instance _124_t1 r0 *1 0,0
R_124_t1 \$124__t1 \$124 25.28745
* device instance _124 r0 *1 0,0
C_124 \$124 vsubs 1.599507e-15
* device instance _13_t0 r0 *1 0,0
R_13_t0 \$13__t0 \$13 979.748226084
* device instance _13_t1 r0 *1 0,0
R_13_t1 \$13__t1 \$13 827.153205074
* device instance _13_t2 r0 *1 0,0
R_13_t2 \$13__t2 \$13 3874.61260019
* device instance _13_t3 r0 *1 0,0
R_13_t3 \$13__t3 \$13 2173.53656866
* device instance _13 r0 *1 0,0
C_13 \$13 vsubs 8.4773094e-14
* device instance _132_t0 r0 *1 0,0
R_132_t0 \$132__t0 \$132 25.28745
* device instance _132_t1 r0 *1 0,0
R_132_t1 \$132__t1 \$132 25.28745
* device instance _132 r0 *1 0,0
C_132 \$132 vsubs 1.599507e-15
* device instance _133_t0 r0 *1 0,0
R_133_t0 \$133__t0 \$133 25.28745
* device instance _133_t1 r0 *1 0,0
R_133_t1 \$133__t1 \$133 25.28745
* device instance _133 r0 *1 0,0
C_133 \$133 vsubs 1.599507e-15
* device instance _134_t0 r0 *1 0,0
R_134_t0 \$134__t0 \$134 25.28745
* device instance _134_t1 r0 *1 0,0
R_134_t1 \$134__t1 \$134 25.28745
* device instance _134 r0 *1 0,0
C_134 \$134 vsubs 1.599507e-15
* device instance _135_t0 r0 *1 0,0
R_135_t0 \$135__t0 \$135 25.28745
* device instance _135_t1 r0 *1 0,0
R_135_t1 \$135__t1 \$135 25.28745
* device instance _135 r0 *1 0,0
C_135 \$135 vsubs 1.599507e-15
* device instance _136_t0 r0 *1 0,0
R_136_t0 \$136__t0 \$136 25.28745
* device instance _136_t1 r0 *1 0,0
R_136_t1 \$136__t1 \$136 25.28745
* device instance _136 r0 *1 0,0
C_136 \$136 vsubs 1.599507e-15
* device instance _137_t0 r0 *1 0,0
R_137_t0 \$137__t0 \$137 25.28745
* device instance _137_t1 r0 *1 0,0
R_137_t1 \$137__t1 \$137 25.28745
* device instance _137 r0 *1 0,0
C_137 \$137 vsubs 1.599507e-15
* device instance _138_t0 r0 *1 0,0
R_138_t0 \$138__t0 \$138 25.28745
* device instance _138_t1 r0 *1 0,0
R_138_t1 \$138__t1 \$138 25.28745
* device instance _138 r0 *1 0,0
C_138 \$138 vsubs 1.599507e-15
* device instance _139_t0 r0 *1 0,0
R_139_t0 \$139__t0 \$139 25.28745
* device instance _139_t1 r0 *1 0,0
R_139_t1 \$139__t1 \$139 25.28745
* device instance _139 r0 *1 0,0
C_139 \$139 vsubs 1.599507e-15
* device instance _14_t0 r0 *1 0,0
R_14_t0 \$14__t0 \$14 2208.25155211
* device instance _14_t1 r0 *1 0,0
R_14_t1 \$14__t1 \$14 368.025235243
* device instance _14_t2 r0 *1 0,0
R_14_t2 \$14__t2 \$14 2114.24861265
* device instance _14 r0 *1 0,0
C_14 \$14 vsubs 5.2350545e-14
* device instance _140_t0 r0 *1 0,0
R_140_t0 \$140__t0 \$140 25.28745
* device instance _140_t1 r0 *1 0,0
R_140_t1 \$140__t1 \$140 25.28745
* device instance _140 r0 *1 0,0
C_140 \$140 vsubs 1.599507e-15
* device instance _141_t0 r0 *1 0,0
R_141_t0 \$141__t0 \$141 25.28745
* device instance _141_t1 r0 *1 0,0
R_141_t1 \$141__t1 \$141 25.28745
* device instance _141 r0 *1 0,0
C_141 \$141 vsubs 1.599507e-15
* device instance _142_t0 r0 *1 0,0
R_142_t0 \$142__t0 \$142 25.28745
* device instance _142_t1 r0 *1 0,0
R_142_t1 \$142__t1 \$142 25.28745
* device instance _142 r0 *1 0,0
C_142 \$142 vsubs 1.599507e-15
* device instance _143_t0 r0 *1 0,0
R_143_t0 \$143__t0 \$143 25.28745
* device instance _143_t1 r0 *1 0,0
R_143_t1 \$143__t1 \$143 25.28745
* device instance _143 r0 *1 0,0
C_143 \$143 vsubs 1.599507e-15
* device instance _144_t0 r0 *1 0,0
R_144_t0 \$144__t0 \$144 25.28745
* device instance _144_t1 r0 *1 0,0
R_144_t1 \$144__t1 \$144 25.28745
* device instance _144 r0 *1 0,0
C_144 \$144 vsubs 1.599507e-15
* device instance _145_t0 r0 *1 0,0
R_145_t0 \$145__t0 \$145 25.28745
* device instance _145_t1 r0 *1 0,0
R_145_t1 \$145__t1 \$145 25.28745
* device instance _145 r0 *1 0,0
C_145 \$145 vsubs 1.599507e-15
* device instance _146_t0 r0 *1 0,0
R_146_t0 \$146__t0 \$146 25.28745
* device instance _146_t1 r0 *1 0,0
R_146_t1 \$146__t1 \$146 25.28745
* device instance _146 r0 *1 0,0
C_146 \$146 vsubs 1.599507e-15
* device instance _147_t0 r0 *1 0,0
R_147_t0 \$147__t0 \$147 25.28745
* device instance _147_t1 r0 *1 0,0
R_147_t1 \$147__t1 \$147 25.28745
* device instance _147 r0 *1 0,0
C_147 \$147 vsubs 1.599507e-15
* device instance _148_t0 r0 *1 0,0
R_148_t0 \$148__t0 \$148 25.28745
* device instance _148_t1 r0 *1 0,0
R_148_t1 \$148__t1 \$148 25.28745
* device instance _148 r0 *1 0,0
C_148 \$148 vsubs 1.599507e-15
* device instance _149_t0 r0 *1 0,0
R_149_t0 \$149__t0 \$149 25.28745
* device instance _149_t1 r0 *1 0,0
R_149_t1 \$149__t1 \$149 25.28745
* device instance _149 r0 *1 0,0
C_149 \$149 vsubs 1.599507e-15
* device instance _15_t0 r0 *1 0,0
R_15_t0 \$15__t0 \$15 798.735608557
* device instance _15_t1 r0 *1 0,0
R_15_t1 \$15__t1 \$15 900.604258303
* device instance _15_t2 r0 *1 0,0
R_15_t2 \$15__t2 \$15 696.871607469
* device instance _15_t3 r0 *1 0,0
R_15_t3 \$15__t3 \$15 2396.20682567
* device instance _15 r0 *1 0,0
C_15 \$15 vsubs 5.9161863e-14
* device instance _150_t0 r0 *1 0,0
R_150_t0 \$150__t0 \$150 25.28745
* device instance _150_t1 r0 *1 0,0
R_150_t1 \$150__t1 \$150 25.28745
* device instance _150 r0 *1 0,0
C_150 \$150 vsubs 1.599507e-15
* device instance _151_t0 r0 *1 0,0
R_151_t0 \$151__t0 \$151 25.28745
* device instance _151_t1 r0 *1 0,0
R_151_t1 \$151__t1 \$151 25.28745
* device instance _151 r0 *1 0,0
C_151 \$151 vsubs 1.599507e-15
* device instance _152_t0 r0 *1 0,0
R_152_t0 \$152__t0 \$152 25.28745
* device instance _152_t1 r0 *1 0,0
R_152_t1 \$152__t1 \$152 25.28745
* device instance _152 r0 *1 0,0
C_152 \$152 vsubs 1.599507e-15
* device instance _16_t0 r0 *1 0,0
R_16_t0 \$16__t0 \$16 764.207687226
* device instance _16_t1 r0 *1 0,0
R_16_t1 \$16__t1 \$16 913.585012659
* device instance _16_t2 r0 *1 0,0
R_16_t2 \$16__t2 \$16 764.207687226
* device instance _16_t3 r0 *1 0,0
R_16_t3 \$16__t3 \$16 2441.99661289
* device instance _16 r0 *1 0,0
C_16 \$16 vsubs 6.0794305e-14
* device instance _17_t0 r0 *1 0,0
R_17_t0 \$17__t0 \$17 486.627728791
* device instance _17_t1 r0 *1 0,0
R_17_t1 \$17__t1 \$17 276.439255717
* device instance _17_t2 r0 *1 0,0
R_17_t2 \$17__t2 \$17 2120.36414661
* device instance _17_t3 r0 *1 0,0
R_17_t3 \$17__t3 \$17 1964.61916888
* device instance _17 r0 *1 0,0
C_17 \$17 vsubs 5.7785044e-14
* device instance _18_t0 r0 *1 0,0
R_18_t0 \$18__t0 \$18 1961.46264717
* device instance _18_t1 r0 *1 0,0
R_18_t1 \$18__t1 \$18 1980.02899168
* device instance _18_t2 r0 *1 0,0
R_18_t2 \$18__t2 \$18 3725.54776115
* device instance _18 r0 *1 0,0
C_18 \$18 vsubs 7.6112691e-14
* device instance _19_t0 r0 *1 0,0
R_19_t0 \$19__t0 \$19 631.9122
* device instance _19_t1 r0 *1 0,0
R_19_t1 \$19__t1 \$19 616.937977251
* device instance _19_t2 r0 *1 0,0
R_19_t2 \$19__t2 \$19 14.9742227488
* device instance _19 r0 *1 0,0
C_19 \$19 vsubs 1.4679011e-14
* device instance _20_t0 r0 *1 0,0
R_20_t0 \$20__t0 \$20 288.034386996
* device instance _20_t1 r0 *1 0,0
R_20_t1 \$20__t1 \$20 288.034386996
* device instance _20_t2 r0 *1 0,0
R_20_t2 \$20__t2 \$20 116.445087634
* device instance _20_t3 r0 *1 0,0
R_20_t3 \$20__t3 \$20 692.332138375
* device instance _20 r0 *1 0,0
C_20 \$20 vsubs 1.5868526e-14
* device instance _21_t0 r0 *1 0,0
R_21_t0 \$21__t0 \$21 261.418858782
* device instance _21_t1 r0 *1 0,0
R_21_t1 \$21__t1 \$21 366.105615344
* device instance _21_t2 r0 *1 0,0
R_21_t2 \$21__t2 \$21 340.793554757
* device instance _21_t3 r0 *1 0,0
R_21_t3 \$21__t3 \$21 324.899769804
* device instance _21_t4 r0 *1 0,0
R_21_t4 \$21__t4 \$21 88.9071013133
* device instance _21 r0 *1 0,0
C_21 \$21 vsubs 1.7766709e-14
* device instance _23_t0 r0 *1 0,0
R_23_t0 \$23__t0 \$23 377.193158999
* device instance _23_t1 r0 *1 0,0
R_23_t1 \$23__t1 \$23 175.868361694
* device instance _23_t2 r0 *1 0,0
R_23_t2 \$23__t2 \$23 253.833596266
* device instance _23_t3 r0 *1 0,0
R_23_t3 \$23__t3 \$23 292.041043747
* device instance _23_t4 r0 *1 0,0
R_23_t4 \$23__t4 \$23 338.946339293
* device instance _23 r0 *1 0,0
C_23 \$23 vsubs 1.7866109e-14
* device instance _24_t0 r0 *1 0,0
R_24_t0 \$24__t0 \$24 630.394143252
* device instance _24_t1 r0 *1 0,0
R_24_t1 \$24__t1 \$24 486.762381087
* device instance _24_t2 r0 *1 0,0
R_24_t2 \$24__t2 \$24 143.96957566
* device instance _24 r0 *1 0,0
C_24 \$24 vsubs 1.3588667e-14
* device instance _25_t0 r0 *1 0,0
R_25_t0 \$25__t0 \$25 122.891188735
* device instance _25_t1 r0 *1 0,0
R_25_t1 \$25__t1 \$25 684.260298411
* device instance _25_t2 r0 *1 0,0
R_25_t2 \$25__t2 \$25 686.317212854
* device instance _25 r0 *1 0,0
C_25 \$25 vsubs 5.2676745e-14
* device instance _26_t0 r0 *1 0,0
R_26_t0 \$26__t0 \$26 715.139441326
* device instance _26_t1 r0 *1 0,0
R_26_t1 \$26__t1 \$26 44.0457601943
* device instance _26_t2 r0 *1 0,0
R_26_t2 \$26__t2 \$26 499.88258088
* device instance _26_t3 r0 *1 0,0
R_26_t3 \$26__t3 \$26 257.887617601
* device instance _26 r0 *1 0,0
C_26 \$26 vsubs 2.1326008e-14
* device instance _27_t0 r0 *1 0,0
R_27_t0 \$27__t0 \$27 212.505970377
* device instance _27_t1 r0 *1 0,0
R_27_t1 \$27__t1 \$27 688.024299088
* device instance _27_t2 r0 *1 0,0
R_27_t2 \$27__t2 \$27 513.046030534
* device instance _27 r0 *1 0,0
C_27 \$27 vsubs 4.4264354e-14
* device instance _28_t0 r0 *1 0,0
R_28_t0 \$28__t0 \$28 2192.18513758
* device instance _28_t1 r0 *1 0,0
R_28_t1 \$28__t1 \$28 119.940253161
* device instance _28_t2 r0 *1 0,0
R_28_t2 \$28__t2 \$28 119.940253161
* device instance _28_t3 r0 *1 0,0
R_28_t3 \$28__t3 \$28 470.418947224
* device instance _28_t4 r0 *1 0,0
R_28_t4 \$28__t4 \$28 753.814003433
* device instance _28_t5 r0 *1 0,0
R_28_t5 \$28__t5 \$28 1044.80236751
* device instance _28_t6 r0 *1 0,0
R_28_t6 \$28__t6 \$28 171.383237922
* device instance _28 r0 *1 0,0
C_28 \$28 vsubs 5.6528747e-14
* device instance _29_t0 r0 *1 0,0
R_29_t0 \$29__t0 \$29 878.61286536
* device instance _29_t1 r0 *1 0,0
R_29_t1 \$29__t1 \$29 878.61286536
* device instance _29_t2 r0 *1 0,0
R_29_t2 \$29__t2 \$29 479.294941313
* device instance _29_t3 r0 *1 0,0
R_29_t3 \$29__t3 \$29 418.160636306
* device instance _29_t4 r0 *1 0,0
R_29_t4 \$29__t4 \$29 1807.81299166
* device instance _29 r0 *1 0,0
C_29 \$29 vsubs 4.7374149e-14
* device instance _30_t0 r0 *1 0,0
R_30_t0 \$30__t0 \$30 1968.54035
* device instance _30_t1 r0 *1 0,0
R_30_t1 \$30__t1 \$30 1968.54035
* device instance _30 r0 *1 0,0
C_30 \$30 vsubs 3.4262384e-14
* device instance _31_t0 r0 *1 0,0
R_31_t0 \$31__t0 \$31 818.584937735
* device instance _31_t1 r0 *1 0,0
R_31_t1 \$31__t1 \$31 602.446318769
* device instance _31_t2 r0 *1 0,0
R_31_t2 \$31__t2 \$31 405.068343117
* device instance _31_t3 r0 *1 0,0
R_31_t3 \$31__t3 \$31 870.985079265
* device instance _31_t4 r0 *1 0,0
R_31_t4 \$31__t4 \$31 837.510194981
* device instance _31_t5 r0 *1 0,0
R_31_t5 \$31__t5 \$31 654.828626133
* device instance _31 r0 *1 0,0
C_31 \$31 vsubs 4.2322747e-14
* device instance _32_t0 r0 *1 0,0
R_32_t0 \$32__t0 \$32 1055.41000903
* device instance _32_t1 r0 *1 0,0
R_32_t1 \$32__t1 \$32 1048.31915217
* device instance _32_t2 r0 *1 0,0
R_32_t2 \$32__t2 \$32 978.029067333
* device instance _32_t3 r0 *1 0,0
R_32_t3 \$32__t3 \$32 985.115471459
* device instance _32 r0 *1 0,0
C_32 \$32 vsubs 3.8921287e-14
* device instance _33_t0 r0 *1 0,0
R_33_t0 \$33__t0 \$33 851.440640246
* device instance _33_t1 r0 *1 0,0
R_33_t1 \$33__t1 \$33 2004.66951985
* device instance _33_t2 r0 *1 0,0
R_33_t2 \$33__t2 \$33 526.661303231
* device instance _33_t3 r0 *1 0,0
R_33_t3 \$33__t3 \$33 626.580236676
* device instance _33 r0 *1 0,0
C_33 \$33 vsubs 3.9492693e-14
* device instance _34_t0 r0 *1 0,0
R_34_t0 \$34__t0 \$34 1969.9799
* device instance _34_t1 r0 *1 0,0
R_34_t1 \$34__t1 \$34 1969.9799
* device instance _34 r0 *1 0,0
C_34 \$34 vsubs 3.5401418e-14
* device instance _35_t0 r0 *1 0,0
R_35_t0 \$35__t0 \$35 1968.36045
* device instance _35_t1 r0 *1 0,0
R_35_t1 \$35__t1 \$35 1968.36045
* device instance _35 r0 *1 0,0
C_35 \$35 vsubs 3.4117005e-14
* device instance _36_t0 r0 *1 0,0
R_36_t0 \$36__t0 \$36 1969.2657
* device instance _36_t1 r0 *1 0,0
R_36_t1 \$36__t1 \$36 1969.2657
* device instance _36 r0 *1 0,0
C_36 \$36 vsubs 3.4836444e-14
* device instance _37_t0 r0 *1 0,0
R_37_t0 \$37__t0 \$37 577.101205748
* device instance _37_t1 r0 *1 0,0
R_37_t1 \$37__t1 \$37 386.186232677
* device instance _37_t2 r0 *1 0,0
R_37_t2 \$37__t2 \$37 754.19830579
* device instance _37_t3 r0 *1 0,0
R_37_t3 \$37__t3 \$37 2034.86326663
* device instance _37_t4 r0 *1 0,0
R_37_t4 \$37__t4 \$37 198.604997756
* device instance _37_t5 r0 *1 0,0
R_37_t5 \$37__t5 \$37 125.223191397
* device instance _37 r0 *1 0,0
C_37 \$37 vsubs 4.4183369e-14
* device instance _39_t0 r0 *1 0,0
R_39_t0 \$39__t0 \$39 2437.59006439
* device instance _39_t1 r0 *1 0,0
R_39_t1 \$39__t1 \$39 762.895630051
* device instance _39_t2 r0 *1 0,0
R_39_t2 \$39__t2 \$39 913.50607551
* device instance _39_t3 r0 *1 0,0
R_39_t3 \$39__t3 \$39 762.895630051
* device instance _39 r0 *1 0,0
C_39 \$39 vsubs 5.7923066e-14
* device instance _40_t0 r0 *1 0,0
R_40_t0 \$40__t0 \$40 648.721578834
* device instance _40_t1 r0 *1 0,0
R_40_t1 \$40__t1 \$40 1279.90073207
* device instance _40_t2 r0 *1 0,0
R_40_t2 \$40__t2 \$40 597.005875788
* device instance _40_t3 r0 *1 0,0
R_40_t3 \$40__t3 \$40 1204.49559346
* device instance _40_t4 r0 *1 0,0
R_40_t4 \$40__t4 \$40 1128.46241984
* device instance _40 r0 *1 0,0
C_40 \$40 vsubs 6.414389e-14
* device instance _41_t0 r0 *1 0,0
R_41_t0 \$41__t0 \$41 2409.42555
* device instance _41_t1 r0 *1 0,0
R_41_t1 \$41__t1 \$41 1204.712775
* device instance _41_t2 r0 *1 0,0
R_41_t2 \$41__t2 \$41 1204.712775
* device instance _41 r0 *1 0,0
C_41 \$41 vsubs 5.4330567e-14
* device instance _42_t0 r0 *1 0,0
R_42_t0 \$42__t0 \$42 2409.69555
* device instance _42_t1 r0 *1 0,0
R_42_t1 \$42__t1 \$42 1204.847775
* device instance _42_t2 r0 *1 0,0
R_42_t2 \$42__t2 \$42 1204.847775
* device instance _42 r0 *1 0,0
C_42 \$42 vsubs 5.4548635e-14
* device instance _43_t0 r0 *1 0,0
R_43_t0 \$43__t0 \$43 2409.9655
* device instance _43_t1 r0 *1 0,0
R_43_t1 \$43__t1 \$43 1204.98275
* device instance _43_t2 r0 *1 0,0
R_43_t2 \$43__t2 \$43 1204.98275
* device instance _43 r0 *1 0,0
C_43 \$43 vsubs 5.4766704e-14
* device instance _44_t0 r0 *1 0,0
R_44_t0 \$44__t0 \$44 2410.2355
* device instance _44_t1 r0 *1 0,0
R_44_t1 \$44__t1 \$44 1205.11775
* device instance _44_t2 r0 *1 0,0
R_44_t2 \$44__t2 \$44 1205.11775
* device instance _44 r0 *1 0,0
C_44 \$44 vsubs 5.4984773e-14
* device instance _45_t0 r0 *1 0,0
R_45_t0 \$45__t0 \$45 1400.6452
* device instance _45_t1 r0 *1 0,0
R_45_t1 \$45__t1 \$45 1400.6452
* device instance _45 r0 *1 0,0
C_45 \$45 vsubs 3.1064128e-14
* device instance _46_t0 r0 *1 0,0
R_46_t0 \$46__t0 \$46 275.91173659
* device instance _46_t1 r0 *1 0,0
R_46_t1 \$46__t1 \$46 1152.10022722
* device instance _46_t2 r0 *1 0,0
R_46_t2 \$46__t2 \$46 72.3260567335
* device instance _46_t3 r0 *1 0,0
R_46_t3 \$46__t3 \$46 275.91173659
* device instance _46_t4 r0 *1 0,0
R_46_t4 \$46__t4 \$46 212.391588062
* device instance _46_t5 r0 *1 0,0
R_46_t5 \$46__t5 \$46 246.208725544
* device instance _46_t6 r0 *1 0,0
R_46_t6 \$46__t6 \$46 340.597144123
* device instance _46_t7 r0 *1 0,0
R_46_t7 \$46__t7 \$46 72.3260567335
* device instance _46_t8 r0 *1 0,0
R_46_t8 \$46__t8 \$46 144.012528403
* device instance _46 r0 *1 0,0
C_46 \$46 vsubs 7.4190842e-14
* device instance _47_t0 r0 *1 0,0
R_47_t0 \$47__t0 \$47 954.603905263
* device instance _47_t1 r0 *1 0,0
R_47_t1 \$47__t1 \$47 1014.07506597
* device instance _47_t2 r0 *1 0,0
R_47_t2 \$47__t2 \$47 740.648776922
* device instance _47_t3 r0 *1 0,0
R_47_t3 \$47__t3 \$47 719.797860447
* device instance _47_t4 r0 *1 0,0
R_47_t4 \$47__t4 \$47 671.322091399
* device instance _47 r0 *1 0,0
C_47 \$47 vsubs 5.2682376e-14
* device instance _48_t0 r0 *1 0,0
R_48_t0 \$48__t0 \$48 921.604176272
* device instance _48_t1 r0 *1 0,0
R_48_t1 \$48__t1 \$48 550.192925008
* device instance _48_t2 r0 *1 0,0
R_48_t2 \$48__t2 \$48 450.44845788
* device instance _48_t3 r0 *1 0,0
R_48_t3 \$48__t3 \$48 646.825671411
* device instance _48_t4 r0 *1 0,0
R_48_t4 \$48__t4 \$48 295.351686536
* device instance _48_t5 r0 *1 0,0
R_48_t5 \$48__t5 \$48 892.679198138
* device instance _48_t6 r0 *1 0,0
R_48_t6 \$48__t6 \$48 305.553184754
* device instance _48 r0 *1 0,0
C_48 \$48 vsubs 8.4701074e-14
* device instance _49_t0 r0 *1 0,0
R_49_t0 \$49__t0 \$49 694.201632009
* device instance _49_t1 r0 *1 0,0
R_49_t1 \$49__t1 \$49 1101.25331834
* device instance _49_t2 r0 *1 0,0
R_49_t2 \$49__t2 \$49 928.634222318
* device instance _49_t3 r0 *1 0,0
R_49_t3 \$49__t3 \$49 1336.10142733
* device instance _49 r0 *1 0,0
C_49 \$49 vsubs 3.9432796e-14
* device instance _50_t0 r0 *1 0,0
R_50_t0 \$50__t0 \$50 9.125
* device instance _50_t1 r0 *1 0,0
R_50_t1 \$50__t1 \$50 9.125
* device instance _50 r0 *1 0,0
C_50 \$50 vsubs 1.8067e-15
* device instance _51_t0 r0 *1 0,0
R_51_t0 \$51__t0 \$51 9.125
* device instance _51_t1 r0 *1 0,0
R_51_t1 \$51__t1 \$51 9.125
* device instance _51 r0 *1 0,0
C_51 \$51 vsubs 1.8067e-15
* device instance _52_t0 r0 *1 0,0
R_52_t0 \$52__t0 \$52 9.125
* device instance _52_t1 r0 *1 0,0
R_52_t1 \$52__t1 \$52 9.125
* device instance _52 r0 *1 0,0
C_52 \$52 vsubs 1.8067e-15
* device instance _53_t0 r0 *1 0,0
R_53_t0 \$53__t0 \$53 9.125
* device instance _53_t1 r0 *1 0,0
R_53_t1 \$53__t1 \$53 9.125
* device instance _53 r0 *1 0,0
C_53 \$53 vsubs 1.8067e-15
* device instance _54_t0 r0 *1 0,0
R_54_t0 \$54__t0 \$54 9.125
* device instance _54_t1 r0 *1 0,0
R_54_t1 \$54__t1 \$54 9.125
* device instance _54 r0 *1 0,0
C_54 \$54 vsubs 1.8067e-15
* device instance _55_t0 r0 *1 0,0
R_55_t0 \$55__t0 \$55 9.125
* device instance _55_t1 r0 *1 0,0
R_55_t1 \$55__t1 \$55 9.125
* device instance _55 r0 *1 0,0
C_55 \$55 vsubs 1.8067e-15
* device instance _56_t0 r0 *1 0,0
R_56_t0 \$56__t0 \$56 9.125
* device instance _56_t1 r0 *1 0,0
R_56_t1 \$56__t1 \$56 9.125
* device instance _56 r0 *1 0,0
C_56 \$56 vsubs 1.8067e-15
* device instance _57_t0 r0 *1 0,0
R_57_t0 \$57__t0 \$57 9.125
* device instance _57_t1 r0 *1 0,0
R_57_t1 \$57__t1 \$57 9.125
* device instance _57 r0 *1 0,0
C_57 \$57 vsubs 1.8067e-15
* device instance _58_t0 r0 *1 0,0
R_58_t0 \$58__t0 \$58 9.125
* device instance _58_t1 r0 *1 0,0
R_58_t1 \$58__t1 \$58 9.125
* device instance _58 r0 *1 0,0
C_58 \$58 vsubs 1.8067e-15
* device instance _59_t0 r0 *1 0,0
R_59_t0 \$59__t0 \$59 2219.38475185
* device instance _59_t1 r0 *1 0,0
R_59_t1 \$59__t1 \$59 1234.10052238
* device instance _59_t2 r0 *1 0,0
R_59_t2 \$59__t2 \$59 3997.24029431
* device instance _59_t3 r0 *1 0,0
R_59_t3 \$59__t3 \$59 557.864231464
* device instance _59 r0 *1 0,0
C_59 \$59 vsubs 8.7584412e-14
* device instance _6_t0 r0 *1 0,0
R_6_t0 \$6__t0 \$6 636.433597654
* device instance _6_t1 r0 *1 0,0
R_6_t1 \$6__t1 \$6 503.959749741
* device instance _6_t2 r0 *1 0,0
R_6_t2 \$6__t2 \$6 371.362761404
* device instance _6_t3 r0 *1 0,0
R_6_t3 \$6__t3 \$6 883.803713976
* device instance _6_t4 r0 *1 0,0
R_6_t4 \$6__t4 \$6 1322.79824296
* device instance _6_t5 r0 *1 0,0
R_6_t5 \$6__t5 \$6 238.945693911
* device instance _6_t6 r0 *1 0,0
R_6_t6 \$6__t6 \$6 591.351383441
* device instance _6_t7 r0 *1 0,0
R_6_t7 \$6__t7 \$6 546.299356917
* device instance _6 r0 *1 0,0
C_6 \$6 vsubs 7.8120649e-14
* device instance _60_t0 r0 *1 0,0
R_60_t0 \$60__t0 \$60 1393.837
* device instance _60_t1 r0 *1 0,0
R_60_t1 \$60__t1 \$60 1393.837
* device instance _60 r0 *1 0,0
C_60 \$60 vsubs 3.3170077e-14
* device instance _61_t0 r0 *1 0,0
R_61_t0 \$61__t0 \$61 9.125
* device instance _61_t1 r0 *1 0,0
R_61_t1 \$61__t1 \$61 9.125
* device instance _61 r0 *1 0,0
C_61 \$61 vsubs 1.8067e-15
* device instance _62_t0 r0 *1 0,0
R_62_t0 \$62__t0 \$62 9.125
* device instance _62_t1 r0 *1 0,0
R_62_t1 \$62__t1 \$62 9.125
* device instance _62 r0 *1 0,0
C_62 \$62 vsubs 1.8067e-15
* device instance _63_t0 r0 *1 0,0
R_63_t0 \$63__t0 \$63 9.125
* device instance _63_t1 r0 *1 0,0
R_63_t1 \$63__t1 \$63 9.125
* device instance _63 r0 *1 0,0
C_63 \$63 vsubs 1.8067e-15
* device instance _64_t0 r0 *1 0,0
R_64_t0 \$64__t0 \$64 9.125
* device instance _64_t1 r0 *1 0,0
R_64_t1 \$64__t1 \$64 9.125
* device instance _64 r0 *1 0,0
C_64 \$64 vsubs 1.8067e-15
* device instance _65_t0 r0 *1 0,0
R_65_t0 \$65__t0 \$65 9.125
* device instance _65_t1 r0 *1 0,0
R_65_t1 \$65__t1 \$65 9.125
* device instance _65 r0 *1 0,0
C_65 \$65 vsubs 1.8067e-15
* device instance _66_t0 r0 *1 0,0
R_66_t0 \$66__t0 \$66 9.125
* device instance _66_t1 r0 *1 0,0
R_66_t1 \$66__t1 \$66 9.125
* device instance _66 r0 *1 0,0
C_66 \$66 vsubs 1.8067e-15
* device instance _67_t0 r0 *1 0,0
R_67_t0 \$67__t0 \$67 9.125
* device instance _67_t1 r0 *1 0,0
R_67_t1 \$67__t1 \$67 9.125
* device instance _67 r0 *1 0,0
C_67 \$67 vsubs 1.8067e-15
* device instance _68_t0 r0 *1 0,0
R_68_t0 \$68__t0 \$68 9.125
* device instance _68_t1 r0 *1 0,0
R_68_t1 \$68__t1 \$68 9.125
* device instance _68 r0 *1 0,0
C_68 \$68 vsubs 1.8067e-15
* device instance _69_t0 r0 *1 0,0
R_69_t0 \$69__t0 \$69 9.125
* device instance _69_t1 r0 *1 0,0
R_69_t1 \$69__t1 \$69 9.125
* device instance _69 r0 *1 0,0
C_69 \$69 vsubs 1.8067e-15
* device instance _7_t0 r0 *1 0,0
R_7_t0 \$7__t0 \$7 3898.24002795
* device instance _7_t1 r0 *1 0,0
R_7_t1 \$7__t1 \$7 2571.04128444
* device instance _7_t2 r0 *1 0,0
R_7_t2 \$7__t2 \$7 1327.4843876
* device instance _7 r0 *1 0,0
C_7 \$7 vsubs 7.8319844e-14
* device instance _70_t0 r0 *1 0,0
R_70_t0 \$70__t0 \$70 9.125
* device instance _70_t1 r0 *1 0,0
R_70_t1 \$70__t1 \$70 9.125
* device instance _70 r0 *1 0,0
C_70 \$70 vsubs 1.8067e-15
* device instance _71_t0 r0 *1 0,0
R_71_t0 \$71__t0 \$71 9.125
* device instance _71_t1 r0 *1 0,0
R_71_t1 \$71__t1 \$71 9.125
* device instance _71 r0 *1 0,0
C_71 \$71 vsubs 1.8067e-15
* device instance _8_t0 r0 *1 0,0
R_8_t0 \$8__t0 \$8 2435.8789
* device instance _8_t1 r0 *1 0,0
R_8_t1 \$8__t1 \$8 967.291041449
* device instance _8_t2 r0 *1 0,0
R_8_t2 \$8__t2 \$8 734.293929275
* device instance _8_t3 r0 *1 0,0
R_8_t3 \$8__t3 \$8 734.293929275
* device instance _8 r0 *1 0,0
C_8 \$8 vsubs 5.5851412e-14
* device instance _9_t0 r0 *1 0,0
R_9_t0 \$9__t0 \$9 732.273832504
* device instance _9_t1 r0 *1 0,0
R_9_t1 \$9__t1 \$9 171.628406437
* device instance _9_t2 r0 *1 0,0
R_9_t2 \$9__t2 \$9 1341.19339542
* device instance _9_t3 r0 *1 0,0
R_9_t3 \$9__t3 \$9 321.870246222
* device instance _9_t4 r0 *1 0,0
R_9_t4 \$9__t4 \$9 783.709475137
* device instance _9_t5 r0 *1 0,0
R_9_t5 \$9__t5 \$9 769.394856997
* device instance _9_t6 r0 *1 0,0
R_9_t6 \$9__t6 \$9 769.394856997
* device instance _9_t7 r0 *1 0,0
R_9_t7 \$9__t7 \$9 460.379603783
* device instance _9_t8 r0 *1 0,0
R_9_t8 \$9__t8 \$9 46.1556265021
* device instance _9 r0 *1 0,0
C_9 \$9 vsubs 7.9168117e-14
* device instance _95_t0 r0 *1 0,0
R_95_t0 \$95__t0 \$95 25.28745
* device instance _95_t1 r0 *1 0,0
R_95_t1 \$95__t1 \$95 25.28745
* device instance _95 r0 *1 0,0
C_95 \$95 vsubs 1.599507e-15
* device instance _96_t0 r0 *1 0,0
R_96_t0 \$96__t0 \$96 25.28745
* device instance _96_t1 r0 *1 0,0
R_96_t1 \$96__t1 \$96 25.28745
* device instance _96 r0 *1 0,0
C_96 \$96 vsubs 1.599507e-15
* device instance _97_t0 r0 *1 0,0
R_97_t0 \$97__t0 \$97 25.28745
* device instance _97_t1 r0 *1 0,0
R_97_t1 \$97__t1 \$97 25.28745
* device instance _97 r0 *1 0,0
C_97 \$97 vsubs 1.599507e-15
* device instance _98_t0 r0 *1 0,0
R_98_t0 \$98__t0 \$98 25.28745
* device instance _98_t1 r0 *1 0,0
R_98_t1 \$98__t1 \$98 25.28745
* device instance _98 r0 *1 0,0
C_98 \$98 vsubs 1.599507e-15
* device instance _99_t0 r0 *1 0,0
R_99_t0 \$99__t0 \$99 25.28745
* device instance _99_t1 r0 *1 0,0
R_99_t1 \$99__t1 \$99 25.28745
* device instance _99 r0 *1 0,0
C_99 \$99 vsubs 1.599507e-15
* device instance BIAS_OK_t0 r0 *1 0,0
RBIAS_OK_t0 BIAS_OK__t0 BIAS_OK 984.154042318
* device instance BIAS_OK_t1 r0 *1 0,0
RBIAS_OK_t1 BIAS_OK__t1 BIAS_OK 1113.02244149
* device instance BIAS_OK_t2 r0 *1 0,0
RBIAS_OK_t2 BIAS_OK__t2 BIAS_OK 1113.14438776
* device instance BIAS_OK_t3 r0 *1 0,0
RBIAS_OK_t3 BIAS_OK__t3 BIAS_OK 901.35693696
* device instance BIAS_OK_t4 r0 *1 0,0
RBIAS_OK_t4 BIAS_OK__t4 BIAS_OK 2143.19269147
* device instance BIAS_OK r0 *1 0,0
CBIAS_OK BIAS_OK vsubs 1.00869418e-13
* device instance BIAS_OKB_t0 r0 *1 0,0
RBIAS_OKB_t0 BIAS_OKB__t0 BIAS_OKB 744.308889961
* device instance BIAS_OKB_t1 r0 *1 0,0
RBIAS_OKB_t1 BIAS_OKB__t1 BIAS_OKB 59.9080526262
* device instance BIAS_OKB_t2 r0 *1 0,0
RBIAS_OKB_t2 BIAS_OKB__t2 BIAS_OKB 17.0676522536
* device instance BIAS_OKB_t3 r0 *1 0,0
RBIAS_OKB_t3 BIAS_OKB__t3 BIAS_OKB 349.031750011
* device instance BIAS_OKB_t4 r0 *1 0,0
RBIAS_OKB_t4 BIAS_OKB__t4 BIAS_OKB 351.14495704
* device instance BIAS_OKB_t5 r0 *1 0,0
RBIAS_OKB_t5 BIAS_OKB__t5 BIAS_OKB 109.722398109
* device instance BIAS_OKB r0 *1 0,0
CBIAS_OKB BIAS_OKB vsubs 2.1654538e-14
* device instance CTAT_t0 r0 *1 0,0
RCTAT_t0 CTAT__t0 CTAT 270.83535
* device instance CTAT_t1 r0 *1 0,0
RCTAT_t1 CTAT__t1 CTAT 270.83535
* device instance CTAT r0 *1 0,0
CCTAT CTAT vsubs 4.4056706e-14
* device instance EN_RESETn_t0 r0 *1 0,0
REN_RESETn_t0 EN|RESETn__t0 EN|RESETn 791.24889891
* device instance EN_RESETn_t1 r0 *1 0,0
REN_RESETn_t1 EN|RESETn__t1 EN|RESETn 779.942668296
* device instance EN_RESETn_t2 r0 *1 0,0
REN_RESETn_t2 EN|RESETn__t2 EN|RESETn 737.918009822
* device instance EN_RESETn_t3 r0 *1 0,0
REN_RESETn_t3 EN|RESETn__t3 EN|RESETn 798.873287602
* device instance EN_RESETn_t4 r0 *1 0,0
REN_RESETn_t4 EN|RESETn__t4 EN|RESETn 634.332156697
* device instance EN_RESETn_t5 r0 *1 0,0
REN_RESETn_t5 EN|RESETn__t5 EN|RESETn 783.76754696
* device instance EN_RESETn_t6 r0 *1 0,0
REN_RESETn_t6 EN|RESETn__t6 EN|RESETn 717.713144061
* device instance EN_RESETn_t7 r0 *1 0,0
REN_RESETn_t7 EN|RESETn__t7 EN|RESETn 765.302787652
* device instance EN_RESETn r0 *1 0,0
CEN_RESETn EN|RESETn vsubs 2.04212856e-13
* device instance ENB_t0 r0 *1 0,0
RENB_t0 ENB__t0 ENB 171.908381309
* device instance ENB_t1 r0 *1 0,0
RENB_t1 ENB__t1 ENB 163.414676184
* device instance ENB_t2 r0 *1 0,0
RENB_t2 ENB__t2 ENB 137.876093758
* device instance ENB_t3 r0 *1 0,0
RENB_t3 ENB__t3 ENB 421.059618338
* device instance ENB_t4 r0 *1 0,0
RENB_t4 ENB__t4 ENB 95.6628742538
* device instance ENB_t5 r0 *1 0,0
RENB_t5 ENB__t5 ENB 326.623923902
* device instance ENB_t6 r0 *1 0,0
RENB_t6 ENB__t6 ENB 189.999228044
* device instance ENB_t7 r0 *1 0,0
RENB_t7 ENB__t7 ENB 215.772604212
* device instance ENB r0 *1 0,0
CENB ENB vsubs 3.6396628e-14
* device instance IBIAS_t0 r0 *1 0,0
RIBIAS_t0 IBIAS__t0 IBIAS 1846.56371411
* device instance IBIAS_t1 r0 *1 0,0
RIBIAS_t1 IBIAS__t1 IBIAS 358.156513217
* device instance IBIAS_t2 r0 *1 0,0
RIBIAS_t2 IBIAS__t2 IBIAS 349.862548376
* device instance IBIAS_t3 r0 *1 0,0
RIBIAS_t3 IBIAS__t3 IBIAS 1544.2520408
* device instance IBIAS_t4 r0 *1 0,0
RIBIAS_t4 IBIAS__t4 IBIAS 1544.2520408
* device instance IBIAS_t5 r0 *1 0,0
RIBIAS_t5 IBIAS__t5 IBIAS 1608.43360795
* device instance IBIAS_t6 r0 *1 0,0
RIBIAS_t6 IBIAS__t6 IBIAS 1695.92709525
* device instance IBIAS_t7 r0 *1 0,0
RIBIAS_t7 IBIAS__t7 IBIAS 1689.27684279
* device instance IBIAS_t8 r0 *1 0,0
RIBIAS_t8 IBIAS__t8 IBIAS 353.907996709
* device instance IBIAS r0 *1 0,0
CIBIAS IBIAS vsubs 2.41547289e-13
* device instance M1D_t0 r0 *1 0,0
RM1D_t0 M1D__t0 M1D 365.905392247
* device instance M1D_t1 r0 *1 0,0
RM1D_t1 M1D__t1 M1D 365.905392247
* device instance M1D_t2 r0 *1 0,0
RM1D_t2 M1D__t2 M1D 297.344707753
* device instance M1D_t3 r0 *1 0,0
RM1D_t3 M1D__t3 M1D 297.344707753
* device instance M1D r0 *1 0,0
CM1D M1D vsubs 2.6572254e-14
* device instance M2D_t0 r0 *1 0,0
RM2D_t0 M2D__t0 M2D 367.857221648
* device instance M2D_t1 r0 *1 0,0
RM2D_t1 M2D__t1 M2D 367.857221648
* device instance M2D_t2 r0 *1 0,0
RM2D_t2 M2D__t2 M2D 257.619878352
* device instance M2D_t3 r0 *1 0,0
RM2D_t3 M2D__t3 M2D 257.619878352
* device instance M2D r0 *1 0,0
CM2D M2D vsubs 2.5181332e-14
* device instance M3D_t0 r0 *1 0,0
RM3D_t0 M3D__t0 M3D 469.402264286
* device instance M3D_t1 r0 *1 0,0
RM3D_t1 M3D__t1 M3D 469.402264286
* device instance M3D_t2 r0 *1 0,0
RM3D_t2 M3D__t2 M3D 118.304635714
* device instance M3D_t3 r0 *1 0,0
RM3D_t3 M3D__t3 M3D 118.304635714
* device instance M3D r0 *1 0,0
CM3D M3D vsubs 2.3790409e-14
* device instance N1_t0 r0 *1 0,0
RN1_t0 N1__t0 N1 534.627163629
* device instance N1_t1 r0 *1 0,0
RN1_t1 N1__t1 N1 378.085819054
* device instance N1_t2 r0 *1 0,0
RN1_t2 N1__t2 N1 243.963010283
* device instance N1_t3 r0 *1 0,0
RN1_t3 N1__t3 N1 188.503038543
* device instance N1_t4 r0 *1 0,0
RN1_t4 N1__t4 N1 534.627163629
* device instance N1_t5 r0 *1 0,0
RN1_t5 N1__t5 N1 188.503038543
* device instance N1_t6 r0 *1 0,0
RN1_t6 N1__t6 N1 1046.59861862
* device instance N1_t7 r0 *1 0,0
RN1_t7 N1__t7 N1 801.166547704
* device instance N1 r0 *1 0,0
CN1 N1 vsubs 3.9158003e-14
* device instance N2_t0 r0 *1 0,0
RN2_t0 N2__t0 N2 667.28572049
* device instance N2_t1 r0 *1 0,0
RN2_t1 N2__t1 N2 392.018582259
* device instance N2_t2 r0 *1 0,0
RN2_t2 N2__t2 N2 145.839569879
* device instance N2_t3 r0 *1 0,0
RN2_t3 N2__t3 N2 198.053465004
* device instance N2_t4 r0 *1 0,0
RN2_t4 N2__t4 N2 225.570429521
* device instance N2_t5 r0 *1 0,0
RN2_t5 N2__t5 N2 356.362337093
* device instance N2_t6 r0 *1 0,0
RN2_t6 N2__t6 N2 374.421195754
* device instance N2 r0 *1 0,0
CN2 N2 vsubs 5.5687914e-14
* device instance NA_t0 r0 *1 0,0
RNA_t0 NA__t0 NA 299.987016677
* device instance NA_t1 r0 *1 0,0
RNA_t1 NA__t1 NA 782.211458547
* device instance NA_t2 r0 *1 0,0
RNA_t2 NA__t2 NA 91.0640100894
* device instance NA_t3 r0 *1 0,0
RNA_t3 NA__t3 NA 177.9098074
* device instance NA_t4 r0 *1 0,0
RNA_t4 NA__t4 NA 432.588253149
* device instance NA_t5 r0 *1 0,0
RNA_t5 NA__t5 NA 389.407654138
* device instance NA r0 *1 0,0
CNA NA vsubs 7.726204e-14
* device instance NB_t0 r0 *1 0,0
RNB_t0 NB__t0 NB 875.385865849
* device instance NB_t1 r0 *1 0,0
RNB_t1 NB__t1 NB 66.6687788692
* device instance NB_t2 r0 *1 0,0
RNB_t2 NB__t2 NB 134.537436555
* device instance NB_t3 r0 *1 0,0
RNB_t3 NB__t3 NB 481.341493586
* device instance NB_t4 r0 *1 0,0
RNB_t4 NB__t4 NB 509.685725141
* device instance NB r0 *1 0,0
CNB NB vsubs 4.7120272e-14
* device instance NBG_t0 r0 *1 0,0
RNBG_t0 NBG__t0 NBG 319.655393327
* device instance NBG_t1 r0 *1 0,0
RNBG_t1 NBG__t1 NBG 497.957181646
* device instance NBG_t2 r0 *1 0,0
RNBG_t2 NBG__t2 NBG 72.3456579667
* device instance NBG_t3 r0 *1 0,0
RNBG_t3 NBG__t3 NBG 74.3376726087
* device instance NBG_t4 r0 *1 0,0
RNBG_t4 NBG__t4 NBG 180.635494451
* device instance NBG r0 *1 0,0
CNBG NBG vsubs 2.6929172e-14
* device instance NC_t0 r0 *1 0,0
RNC_t0 NC__t0 NC 58.0128241616
* device instance NC_t1 r0 *1 0,0
RNC_t1 NC__t1 NC 5.17314575229
* device instance NC_t2 r0 *1 0,0
RNC_t2 NC__t2 NC 8.42906808227
* device instance NC_t3 r0 *1 0,0
RNC_t3 NC__t3 NC 12.3918471968
* device instance NC_t4 r0 *1 0,0
RNC_t4 NC__t4 NC 2.88062399517
* device instance NC_t5 r0 *1 0,0
RNC_t5 NC__t5 NC 12.4439514887
* device instance NC_t6 r0 *1 0,0
RNC_t6 NC__t6 NC 8.50548296342
* device instance NC_t7 r0 *1 0,0
RNC_t7 NC__t7 NC 5.29674321447
* device instance NC_t8 r0 *1 0,0
RNC_t8 NC__t8 NC 11.6230131453
* device instance NC r0 *1 0,0
CNC NC vsubs 1.06239997e-13
* device instance ND_t0 r0 *1 0,0
RND_t0 ND__t0 ND 229.124892636
* device instance ND_t1 r0 *1 0,0
RND_t1 ND__t1 ND 685.527951368
* device instance ND_t2 r0 *1 0,0
RND_t2 ND__t2 ND 219.61306336
* device instance ND_t3 r0 *1 0,0
RND_t3 ND__t3 ND 378.405592635
* device instance ND r0 *1 0,0
CND ND vsubs 3.4731319e-14
* device instance NR_t0 r0 *1 0,0
RNR_t0 NR__t0 NR 286.922700175
* device instance NR_t1 r0 *1 0,0
RNR_t1 NR__t1 NR 286.922700175
* device instance NR_t2 r0 *1 0,0
RNR_t2 NR__t2 NR 356.720721034
* device instance NR_t3 r0 *1 0,0
RNR_t3 NR__t3 NR 764.350678615
* device instance NR r0 *1 0,0
CNR NR vsubs 3.5361036e-14
* device instance NT_t0 r0 *1 0,0
RNT_t0 NT__t0 NT 97.5193258677
* device instance NT_t1 r0 *1 0,0
RNT_t1 NT__t1 NT 2593.74803582
* device instance NT_t2 r0 *1 0,0
RNT_t2 NT__t2 NT 330.085678635
* device instance NT_t3 r0 *1 0,0
RNT_t3 NT__t3 NT 24.5247259175
* device instance NT_t4 r0 *1 0,0
RNT_t4 NT__t4 NT 330.085678635
* device instance NT_t5 r0 *1 0,0
RNT_t5 NT__t5 NT 24.5247259175
* device instance NT_t6 r0 *1 0,0
RNT_t6 NT__t6 NT 134.599552202
* device instance NT_t7 r0 *1 0,0
RNT_t7 NT__t7 NT 199.46944143
* device instance NT_t8 r0 *1 0,0
RNT_t8 NT__t8 NT 264.703412634
* device instance NT_t9 r0 *1 0,0
RNT_t9 NT__t9 NT 330.085678635
* device instance NT_t10 r0 *1 0,0
RNT_t10 NT__t10 NT 71.0974037861
* device instance NT_t11 r0 *1 0,0
RNT_t11 NT__t11 NT 24.5247259175
* device instance NT_t12 r0 *1 0,0
RNT_t12 NT__t12 NT 134.599552202
* device instance NT_t13 r0 *1 0,0
RNT_t13 NT__t13 NT 199.46944143
* device instance NT_t14 r0 *1 0,0
RNT_t14 NT__t14 NT 264.703412634
* device instance NT_t15 r0 *1 0,0
RNT_t15 NT__t15 NT 330.085678635
* device instance NT_t16 r0 *1 0,0
RNT_t16 NT__t16 NT 71.0974037861
* device instance NT_t17 r0 *1 0,0
RNT_t17 NT__t17 NT 24.5247259175
* device instance NT r0 *1 0,0
CNT NT vsubs 8.5988494e-14
* device instance NZ_t0 r0 *1 0,0
RNZ_t0 NZ__t0 NZ 59.5605
* device instance NZ_t1 r0 *1 0,0
RNZ_t1 NZ__t1 NZ 59.5605
* device instance NZ r0 *1 0,0
CNZ NZ vsubs 3.4541994e-14
* device instance PB_t0 r0 *1 0,0
RPB_t0 PB__t0 PB 1632.9207003
* device instance PB_t1 r0 *1 0,0
RPB_t1 PB__t1 PB 118.157609212
* device instance PB_t2 r0 *1 0,0
RPB_t2 PB__t2 PB 328.441785264
* device instance PB_t3 r0 *1 0,0
RPB_t3 PB__t3 PB 645.862714873
* device instance PB_t4 r0 *1 0,0
RPB_t4 PB__t4 PB 328.441785264
* device instance PB_t5 r0 *1 0,0
RPB_t5 PB__t5 PB 481.85070509
* device instance PB r0 *1 0,0
CPB PB vsubs 4.7116177e-14
* device instance PCAS_t0 r0 *1 0,0
RPCAS_t0 PCAS__t0 PCAS 810.502975562
* device instance PCAS_t1 r0 *1 0,0
RPCAS_t1 PCAS__t1 PCAS 758.177517915
* device instance PCAS_t2 r0 *1 0,0
RPCAS_t2 PCAS__t2 PCAS 758.177517915
* device instance PCAS_t3 r0 *1 0,0
RPCAS_t3 PCAS__t3 PCAS 101.088066233
* device instance PCAS_t4 r0 *1 0,0
RPCAS_t4 PCAS__t4 PCAS 648.949250633
* device instance PCAS_t5 r0 *1 0,0
RPCAS_t5 PCAS__t5 PCAS 389.130532764
* device instance PCAS_t6 r0 *1 0,0
RPCAS_t6 PCAS__t6 PCAS 518.763990671
* device instance PCAS_t7 r0 *1 0,0
RPCAS_t7 PCAS__t7 PCAS 218.391841544
* device instance PCAS_t8 r0 *1 0,0
RPCAS_t8 PCAS__t8 PCAS 345.683006763
* device instance PCAS r0 *1 0,0
CPCAS PCAS vsubs 5.3717376e-14
* device instance PG_t0 r0 *1 0,0
RPG_t0 PG__t0 PG 666.150692096
* device instance PG_t1 r0 *1 0,0
RPG_t1 PG__t1 PG 430.615978181
* device instance PG_t2 r0 *1 0,0
RPG_t2 PG__t2 PG 83.6375011211
* device instance PG_t3 r0 *1 0,0
RPG_t3 PG__t3 PG 417.439404629
* device instance PG_t4 r0 *1 0,0
RPG_t4 PG__t4 PG 599.142193276
* device instance PG_t5 r0 *1 0,0
RPG_t5 PG__t5 PG 514.848951694
* device instance PG_t6 r0 *1 0,0
RPG_t6 PG__t6 PG 151.271388757
* device instance PG_t7 r0 *1 0,0
RPG_t7 PG__t7 PG 234.368666133
* device instance PG_t8 r0 *1 0,0
RPG_t8 PG__t8 PG 318.177485975
* device instance PG_t9 r0 *1 0,0
RPG_t9 PG__t9 PG 731.227109932
* device instance PG_t10 r0 *1 0,0
RPG_t10 PG__t10 PG 334.099181493
* device instance PG_t11 r0 *1 0,0
RPG_t11 PG__t11 PG 629.340446714
* device instance PG r0 *1 0,0
CPG PG vsubs 6.8097327e-14
* device instance POR_RAW_t0 r0 *1 0,0
RPOR_RAW_t0 POR_RAW__t0 POR_RAW 1629.67210898
* device instance POR_RAW_t1 r0 *1 0,0
RPOR_RAW_t1 POR_RAW__t1 POR_RAW 1233.22826717
* device instance POR_RAW_t2 r0 *1 0,0
RPOR_RAW_t2 POR_RAW__t2 POR_RAW 1092.40942032
* device instance POR_RAW_t3 r0 *1 0,0
RPOR_RAW_t3 POR_RAW__t3 POR_RAW 1488.85430353
* device instance POR_RAW r0 *1 0,0
CPOR_RAW POR_RAW vsubs 9.050824e-14
* device instance PTAT_t0 r0 *1 0,0
RPTAT_t0 PTAT__t0 PTAT 384.810019591
* device instance PTAT_t1 r0 *1 0,0
RPTAT_t1 PTAT__t1 PTAT 164.836688938
* device instance PTAT_t2 r0 *1 0,0
RPTAT_t2 PTAT__t2 PTAT 226.741568323
* device instance PTAT_t3 r0 *1 0,0
RPTAT_t3 PTAT__t3 PTAT 218.610523147
* device instance PTAT r0 *1 0,0
CPTAT PTAT vsubs 5.1111964e-14
* device instance T0_t0 r0 *1 0,0
RT0_t0 T0__t0 T0 320.043026094
* device instance T0_t1 r0 *1 0,0
RT0_t1 T0__t1 T0 313.559674231
* device instance T0_t2 r0 *1 0,0
RT0_t2 T0__t2 T0 312.817780188
* device instance T0_t3 r0 *1 0,0
RT0_t3 T0__t3 T0 320.719719486
* device instance T0 r0 *1 0,0
CT0 T0 vsubs 6.0943107e-14
* device instance T1_t0 r0 *1 0,0
RT1_t0 T1__t0 T1 309.075824733
* device instance T1_t1 r0 *1 0,0
RT1_t1 T1__t1 T1 305.716375402
* device instance T1_t2 r0 *1 0,0
RT1_t2 T1__t2 T1 315.094088938
* device instance T1_t3 r0 *1 0,0
RT1_t3 T1__t3 T1 299.558010926
* device instance T1 r0 *1 0,0
CT1 T1 vsubs 6.0274424e-14
* device instance T2_t0 r0 *1 0,0
RT2_t0 T2__t0 T2 296.459639641
* device instance T2_t1 r0 *1 0,0
RT2_t1 T2__t1 T2 299.620848801
* device instance T2_t2 r0 *1 0,0
RT2_t2 T2__t2 T2 286.687901974
* device instance T2_t3 r0 *1 0,0
RT2_t3 T2__t3 T2 308.985109584
* device instance T2 r0 *1 0,0
CT2 T2 vsubs 5.9605742e-14
* device instance T3_t0 r0 *1 0,0
RT3_t0 T3__t0 T3 280.061751539
* device instance T3_t1 r0 *1 0,0
RT3_t1 T3__t1 T3 297.643350284
* device instance T3_t2 r0 *1 0,0
RT3_t2 T3__t2 T3 301.967758756
* device instance T3_t3 r0 *1 0,0
RT3_t3 T3__t3 T3 274.39563942
* device instance T3 r0 *1 0,0
CT3 T3 vsubs 5.8937059e-14
* device instance T4_t0 r0 *1 0,0
RT4_t0 T4__t0 T4 292.687741783
* device instance T4_t1 r0 *1 0,0
RT4_t1 T4__t1 T4 256.490260142
* device instance T4_t2 r0 *1 0,0
RT4_t2 T4__t2 T4 303.654865819
* device instance T4_t3 r0 *1 0,0
RT4_t3 T4__t3 T4 263.556832256
* device instance T4 r0 *1 0,0
CT4 T4 vsubs 5.8268377e-14
* device instance T5_t0 r0 *1 0,0
RT5_t0 T5__t0 T5 311.783920291
* device instance T5_t1 r0 *1 0,0
RT5_t1 T5__t1 T5 160.212156364
* device instance T5_t2 r0 *1 0,0
RT5_t2 T5__t2 T5 151.573623345
* device instance T5 r0 *1 0,0
CT5 T5 vsubs 5.1212691e-14
* device instance VDD_t0 r0 *1 0,0
RVDD_t0 VDD__t0 VDD 65.2196284139
* device instance VDD_t1 r0 *1 0,0
RVDD_t1 VDD__t1 VDD 111.778676745
* device instance VDD_t2 r0 *1 0,0
RVDD_t2 VDD__t2 VDD 111.778676745
* device instance VDD_t3 r0 *1 0,0
RVDD_t3 VDD__t3 VDD 107.275072116
* device instance VDD_t4 r0 *1 0,0
RVDD_t4 VDD__t4 VDD 107.275072116
* device instance VDD_t5 r0 *1 0,0
RVDD_t5 VDD__t5 VDD 101.94806792
* device instance VDD_t6 r0 *1 0,0
RVDD_t6 VDD__t6 VDD 101.94806792
* device instance VDD_t7 r0 *1 0,0
RVDD_t7 VDD__t7 VDD 100.075862715
* device instance VDD_t8 r0 *1 0,0
RVDD_t8 VDD__t8 VDD 96.2690313262
* device instance VDD_t9 r0 *1 0,0
RVDD_t9 VDD__t9 VDD 96.2690313262
* device instance VDD_t10 r0 *1 0,0
RVDD_t10 VDD__t10 VDD 75.7792586374
* device instance VDD_t11 r0 *1 0,0
RVDD_t11 VDD__t11 VDD 75.7792586374
* device instance VDD_t12 r0 *1 0,0
RVDD_t12 VDD__t12 VDD 48.8200904995
* device instance VDD_t13 r0 *1 0,0
RVDD_t13 VDD__t13 VDD 49.5355972853
* device instance VDD_t14 r0 *1 0,0
RVDD_t14 VDD__t14 VDD 49.5355972853
* device instance VDD_t15 r0 *1 0,0
RVDD_t15 VDD__t15 VDD 50.1182660872
* device instance VDD_t16 r0 *1 0,0
RVDD_t16 VDD__t16 VDD 50.1182660872
* device instance VDD_t17 r0 *1 0,0
RVDD_t17 VDD__t17 VDD 179.00486924
* device instance VDD_t18 r0 *1 0,0
RVDD_t18 VDD__t18 VDD 179.00486924
* device instance VDD_t19 r0 *1 0,0
RVDD_t19 VDD__t19 VDD 185.288298454
* device instance VDD_t20 r0 *1 0,0
RVDD_t20 VDD__t20 VDD 185.288298454
* device instance VDD_t21 r0 *1 0,0
RVDD_t21 VDD__t21 VDD 188.876304233
* device instance VDD_t22 r0 *1 0,0
RVDD_t22 VDD__t22 VDD 188.876304233
* device instance VDD_t23 r0 *1 0,0
RVDD_t23 VDD__t23 VDD 194.186876568
* device instance VDD_t24 r0 *1 0,0
RVDD_t24 VDD__t24 VDD 195.206467814
* device instance VDD_t25 r0 *1 0,0
RVDD_t25 VDD__t25 VDD 195.206467814
* device instance VDD_t26 r0 *1 0,0
RVDD_t26 VDD__t26 VDD 197.037700427
* device instance VDD_t27 r0 *1 0,0
RVDD_t27 VDD__t27 VDD 197.977292435
* device instance VDD_t28 r0 *1 0,0
RVDD_t28 VDD__t28 VDD 203.859238701
* device instance VDD_t29 r0 *1 0,0
RVDD_t29 VDD__t29 VDD 203.859238701
* device instance VDD_t30 r0 *1 0,0
RVDD_t30 VDD__t30 VDD 36.5662970865
* device instance VDD_t31 r0 *1 0,0
RVDD_t31 VDD__t31 VDD 58.3274659726
* device instance VDD_t32 r0 *1 0,0
RVDD_t32 VDD__t32 VDD 58.3274659726
* device instance VDD_t33 r0 *1 0,0
RVDD_t33 VDD__t33 VDD 117.567986315
* device instance VDD_t34 r0 *1 0,0
RVDD_t34 VDD__t34 VDD 102.663034504
* device instance VDD_t35 r0 *1 0,0
RVDD_t35 VDD__t35 VDD 102.663034504
* device instance VDD_t36 r0 *1 0,0
RVDD_t36 VDD__t36 VDD 117.567986315
* device instance VDD_t37 r0 *1 0,0
RVDD_t37 VDD__t37 VDD 89.4677926207
* device instance VDD_t38 r0 *1 0,0
RVDD_t38 VDD__t38 VDD 89.4677926207
* device instance VDD_t39 r0 *1 0,0
RVDD_t39 VDD__t39 VDD 83.6518696905
* device instance VDD_t40 r0 *1 0,0
RVDD_t40 VDD__t40 VDD 83.6518696905
* device instance VDD_t41 r0 *1 0,0
RVDD_t41 VDD__t41 VDD 81.5256534
* device instance VDD_t42 r0 *1 0,0
RVDD_t42 VDD__t42 VDD 81.5256534
* device instance VDD_t43 r0 *1 0,0
RVDD_t43 VDD__t43 VDD 86.4511067433
* device instance VDD_t44 r0 *1 0,0
RVDD_t44 VDD__t44 VDD 86.4511067433
* device instance VDD_t45 r0 *1 0,0
RVDD_t45 VDD__t45 VDD 101.487726192
* device instance VDD_t46 r0 *1 0,0
RVDD_t46 VDD__t46 VDD 99.7397211536
* device instance VDD_t47 r0 *1 0,0
RVDD_t47 VDD__t47 VDD 98.0226921631
* device instance VDD_t48 r0 *1 0,0
RVDD_t48 VDD__t48 VDD 92.5391522041
* device instance VDD_t49 r0 *1 0,0
RVDD_t49 VDD__t49 VDD 91.4987483055
* device instance VDD_t50 r0 *1 0,0
RVDD_t50 VDD__t50 VDD 94.1403475151
* device instance VDD_t51 r0 *1 0,0
RVDD_t51 VDD__t51 VDD 95.778380467
* device instance VDD_t52 r0 *1 0,0
RVDD_t52 VDD__t52 VDD 101.487726192
* device instance VDD_t53 r0 *1 0,0
RVDD_t53 VDD__t53 VDD 99.7397211536
* device instance VDD_t54 r0 *1 0,0
RVDD_t54 VDD__t54 VDD 98.0226921631
* device instance VDD_t55 r0 *1 0,0
RVDD_t55 VDD__t55 VDD 92.5391522041
* device instance VDD_t56 r0 *1 0,0
RVDD_t56 VDD__t56 VDD 91.4987483055
* device instance VDD_t57 r0 *1 0,0
RVDD_t57 VDD__t57 VDD 94.1403475151
* device instance VDD_t58 r0 *1 0,0
RVDD_t58 VDD__t58 VDD 95.778380467
* device instance VDD_t59 r0 *1 0,0
RVDD_t59 VDD__t59 VDD 102.663034504
* device instance VDD_t60 r0 *1 0,0
RVDD_t60 VDD__t60 VDD 91.4987483055
* device instance VDD_t61 r0 *1 0,0
RVDD_t61 VDD__t61 VDD 102.663034504
* device instance VDD_t62 r0 *1 0,0
RVDD_t62 VDD__t62 VDD 91.4987483055
* device instance VDD_t63 r0 *1 0,0
RVDD_t63 VDD__t63 VDD 64.3107217481
* device instance VDD_t64 r0 *1 0,0
RVDD_t64 VDD__t64 VDD 197.977292435
* device instance VDD_t65 r0 *1 0,0
RVDD_t65 VDD__t65 VDD 192.157035573
* device instance VDD_t66 r0 *1 0,0
RVDD_t66 VDD__t66 VDD 201.757654764
* device instance VDD_t67 r0 *1 0,0
RVDD_t67 VDD__t67 VDD 192.157035573
* device instance VDD_t68 r0 *1 0,0
RVDD_t68 VDD__t68 VDD 201.757654764
* device instance VDD_t69 r0 *1 0,0
RVDD_t69 VDD__t69 VDD 182.275223496
* device instance VDD_t70 r0 *1 0,0
RVDD_t70 VDD__t70 VDD 182.275223496
* device instance VDD_t71 r0 *1 0,0
RVDD_t71 VDD__t71 VDD 196.163586251
* device instance VDD_t72 r0 *1 0,0
RVDD_t72 VDD__t72 VDD 50.4663839903
* device instance VDD_t73 r0 *1 0,0
RVDD_t73 VDD__t73 VDD 82.8658439717
* device instance VDD_t74 r0 *1 0,0
RVDD_t74 VDD__t74 VDD 196.163586251
* device instance VDD_t75 r0 *1 0,0
RVDD_t75 VDD__t75 VDD 50.4663839903
* device instance VDD_t76 r0 *1 0,0
RVDD_t76 VDD__t76 VDD 82.8658439717
* device instance VDD_t77 r0 *1 0,0
RVDD_t77 VDD__t77 VDD 78.5974872418
* device instance VDD_t78 r0 *1 0,0
RVDD_t78 VDD__t78 VDD 199.600157085
* device instance VDD_t79 r0 *1 0,0
RVDD_t79 VDD__t79 VDD 198.790415344
* device instance VDD_t80 r0 *1 0,0
RVDD_t80 VDD__t80 VDD 78.5974872418
* device instance VDD_t81 r0 *1 0,0
RVDD_t81 VDD__t81 VDD 199.600157085
* device instance VDD_t82 r0 *1 0,0
RVDD_t82 VDD__t82 VDD 198.790415344
* device instance VDD_t83 r0 *1 0,0
RVDD_t83 VDD__t83 VDD 93.3350256392
* device instance VDD_t84 r0 *1 0,0
RVDD_t84 VDD__t84 VDD 100.609951905
* device instance VDD_t85 r0 *1 0,0
RVDD_t85 VDD__t85 VDD 97.1763079592
* device instance VDD_t86 r0 *1 0,0
RVDD_t86 VDD__t86 VDD 49.183189221
* device instance VDD_t87 r0 *1 0,0
RVDD_t87 VDD__t87 VDD 98.8772331124
* device instance VDD_t88 r0 *1 0,0
RVDD_t88 VDD__t88 VDD 94.9548774324
* device instance VDD_t89 r0 *1 0,0
RVDD_t89 VDD__t89 VDD 96.6106271605
* device instance VDD_t90 r0 *1 0,0
RVDD_t90 VDD__t90 VDD 79.5545293736
* device instance VDD_t91 r0 *1 0,0
RVDD_t91 VDD__t91 VDD 94.7154807987
* device instance VDD_t92 r0 *1 0,0
RVDD_t92 VDD__t92 VDD 90.1028817945
* device instance VDD_t93 r0 *1 0,0
RVDD_t93 VDD__t93 VDD 88.5827564131
* device instance VDD_t94 r0 *1 0,0
RVDD_t94 VDD__t94 VDD 79.5545293736
* device instance VDD_t95 r0 *1 0,0
RVDD_t95 VDD__t95 VDD 94.7154807987
* device instance VDD_t96 r0 *1 0,0
RVDD_t96 VDD__t96 VDD 90.1028817945
* device instance VDD_t97 r0 *1 0,0
RVDD_t97 VDD__t97 VDD 88.5827564131
* device instance VDD_t98 r0 *1 0,0
RVDD_t98 VDD__t98 VDD 98.4868751243
* device instance VDD_t99 r0 *1 0,0
RVDD_t99 VDD__t99 VDD 105.67567296
* device instance VDD_t100 r0 *1 0,0
RVDD_t100 VDD__t100 VDD 102.493760826
* device instance VDD_t101 r0 *1 0,0
RVDD_t101 VDD__t101 VDD 97.7672226743
* device instance VDD_t102 r0 *1 0,0
RVDD_t102 VDD__t102 VDD 105.67567296
* device instance VDD_t103 r0 *1 0,0
RVDD_t103 VDD__t103 VDD 102.493760826
* device instance VDD_t104 r0 *1 0,0
RVDD_t104 VDD__t104 VDD 97.7672226743
* device instance VDD_t105 r0 *1 0,0
RVDD_t105 VDD__t105 VDD 92.7116499631
* device instance VDD_t106 r0 *1 0,0
RVDD_t106 VDD__t106 VDD 110.159292373
* device instance VDD_t107 r0 *1 0,0
RVDD_t107 VDD__t107 VDD 108.544629975
* device instance VDD_t108 r0 *1 0,0
RVDD_t108 VDD__t108 VDD 91.1662531156
* device instance VDD_t109 r0 *1 0,0
RVDD_t109 VDD__t109 VDD 110.159292373
* device instance VDD_t110 r0 *1 0,0
RVDD_t110 VDD__t110 VDD 108.544629975
* device instance VDD r0 *1 0,0
CVDD VDD vsubs 7.69270398e-13
* device instance VREF_t0 r0 *1 0,0
RVREF_t0 VREF__t0 VREF 1775.35275264
* device instance VREF_t1 r0 *1 0,0
RVREF_t1 VREF__t1 VREF 3191.00030505
* device instance VREF_t2 r0 *1 0,0
RVREF_t2 VREF__t2 VREF 4179.70894231
* device instance VREF r0 *1 0,0
CVREF VREF vsubs 1.27500974e-13
* device instance VSS_t0 r0 *1 0,0
RVSS_t0 VSS__t0 VSS 25.2154251916
* device instance VSS_t1 r0 *1 0,0
RVSS_t1 VSS__t1 VSS 19.1725636954
* device instance VSS_t2 r0 *1 0,0
RVSS_t2 VSS__t2 VSS 18.5496443538
* device instance VSS_t3 r0 *1 0,0
RVSS_t3 VSS__t3 VSS 17.6792311862
* device instance VSS_t4 r0 *1 0,0
RVSS_t4 VSS__t4 VSS 15.3047177725
* device instance VSS_t5 r0 *1 0,0
RVSS_t5 VSS__t5 VSS 15.2349536978
* device instance VSS_t6 r0 *1 0,0
RVSS_t6 VSS__t6 VSS 14.6663253377
* device instance VSS_t7 r0 *1 0,0
RVSS_t7 VSS__t7 VSS 14.3419763563
* device instance VSS_t8 r0 *1 0,0
RVSS_t8 VSS__t8 VSS 12.5734242329
* device instance VSS_t9 r0 *1 0,0
RVSS_t9 VSS__t9 VSS 12.6838927664
* device instance VSS_t10 r0 *1 0,0
RVSS_t10 VSS__t10 VSS 12.802239454
* device instance VSS_t11 r0 *1 0,0
RVSS_t11 VSS__t11 VSS 12.8857380219
* device instance VSS_t12 r0 *1 0,0
RVSS_t12 VSS__t12 VSS 12.7378189321
* device instance VSS_t13 r0 *1 0,0
RVSS_t13 VSS__t13 VSS 13.0769454302
* device instance VSS_t14 r0 *1 0,0
RVSS_t14 VSS__t14 VSS 13.3029489567
* device instance VSS_t15 r0 *1 0,0
RVSS_t15 VSS__t15 VSS 28.4326543923
* device instance VSS_t16 r0 *1 0,0
RVSS_t16 VSS__t16 VSS 29.2516424815
* device instance VSS_t17 r0 *1 0,0
RVSS_t17 VSS__t17 VSS 30.1611595813
* device instance VSS_t18 r0 *1 0,0
RVSS_t18 VSS__t18 VSS 30.6658704726
* device instance VSS_t19 r0 *1 0,0
RVSS_t19 VSS__t19 VSS 31.4450703782
* device instance VSS_t20 r0 *1 0,0
RVSS_t20 VSS__t20 VSS 32.0129633638
* device instance VSS_t21 r0 *1 0,0
RVSS_t21 VSS__t21 VSS 13.6083051134
* device instance VSS_t22 r0 *1 0,0
RVSS_t22 VSS__t22 VSS 11.5696809269
* device instance VSS_t23 r0 *1 0,0
RVSS_t23 VSS__t23 VSS 11.6627231316
* device instance VSS_t24 r0 *1 0,0
RVSS_t24 VSS__t24 VSS 9.89391678895
* device instance VSS_t25 r0 *1 0,0
RVSS_t25 VSS__t25 VSS 28.1811696252
* device instance VSS_t26 r0 *1 0,0
RVSS_t26 VSS__t26 VSS 30.8402844553
* device instance VSS_t27 r0 *1 0,0
RVSS_t27 VSS__t27 VSS 11.5523088217
* device instance VSS_t28 r0 *1 0,0
RVSS_t28 VSS__t28 VSS 13.0647736526
* device instance VSS_t29 r0 *1 0,0
RVSS_t29 VSS__t29 VSS 13.3389594093
* device instance VSS_t30 r0 *1 0,0
RVSS_t30 VSS__t30 VSS 13.6440200053
* device instance VSS_t31 r0 *1 0,0
RVSS_t31 VSS__t31 VSS 13.7224501514
* device instance VSS_t32 r0 *1 0,0
RVSS_t32 VSS__t32 VSS 14.9126071928
* device instance VSS_t33 r0 *1 0,0
RVSS_t33 VSS__t33 VSS 14.6340154949
* device instance VSS_t34 r0 *1 0,0
RVSS_t34 VSS__t34 VSS 14.38453621
* device instance VSS_t35 r0 *1 0,0
RVSS_t35 VSS__t35 VSS 14.2750344822
* device instance VSS_t36 r0 *1 0,0
RVSS_t36 VSS__t36 VSS 13.9837464825
* device instance VSS_t37 r0 *1 0,0
RVSS_t37 VSS__t37 VSS 29.1692129494
* device instance VSS_t38 r0 *1 0,0
RVSS_t38 VSS__t38 VSS 27.6852376712
* device instance VSS_t39 r0 *1 0,0
RVSS_t39 VSS__t39 VSS 29.6403259197
* device instance VSS_t40 r0 *1 0,0
RVSS_t40 VSS__t40 VSS 9.71858231973
* device instance VSS_t41 r0 *1 0,0
RVSS_t41 VSS__t41 VSS 9.63238211599
* device instance VSS_t42 r0 *1 0,0
RVSS_t42 VSS__t42 VSS 9.5471953547
* device instance VSS_t43 r0 *1 0,0
RVSS_t43 VSS__t43 VSS 9.80576923915
* device instance VSS_t44 r0 *1 0,0
RVSS_t44 VSS__t44 VSS 9.71858231973
* device instance VSS_t45 r0 *1 0,0
RVSS_t45 VSS__t45 VSS 11.5548466517
* device instance VSS_t46 r0 *1 0,0
RVSS_t46 VSS__t46 VSS 11.9056668408
* device instance VSS_t47 r0 *1 0,0
RVSS_t47 VSS__t47 VSS 12.2928436123
* device instance VSS_t48 r0 *1 0,0
RVSS_t48 VSS__t48 VSS 12.2371587287
* device instance VSS_t49 r0 *1 0,0
RVSS_t49 VSS__t49 VSS 12.5689488633
* device instance VSS_t50 r0 *1 0,0
RVSS_t50 VSS__t50 VSS 12.9362891387
* device instance VSS_t51 r0 *1 0,0
RVSS_t51 VSS__t51 VSS 10.8820764523
* device instance VSS_t52 r0 *1 0,0
RVSS_t52 VSS__t52 VSS 11.2538886476
* device instance VSS_t53 r0 *1 0,0
RVSS_t53 VSS__t53 VSS 11.2437866727
* device instance VSS_t54 r0 *1 0,0
RVSS_t54 VSS__t54 VSS 12.8266953617
* device instance VSS_t55 r0 *1 0,0
RVSS_t55 VSS__t55 VSS 13.2322265468
* device instance VSS_t56 r0 *1 0,0
RVSS_t56 VSS__t56 VSS 13.1392890586
* device instance VSS_t57 r0 *1 0,0
RVSS_t57 VSS__t57 VSS 12.2544548492
* device instance VSS_t58 r0 *1 0,0
RVSS_t58 VSS__t58 VSS 38.20460511
* device instance VSS_t59 r0 *1 0,0
RVSS_t59 VSS__t59 VSS 32.3862625376
* device instance VSS_t60 r0 *1 0,0
RVSS_t60 VSS__t60 VSS 10.8648631224
* device instance VSS_t61 r0 *1 0,0
RVSS_t61 VSS__t61 VSS 32.5545001769
* device instance VSS_t62 r0 *1 0,0
RVSS_t62 VSS__t62 VSS 31.6309498602
* device instance VSS_t63 r0 *1 0,0
RVSS_t63 VSS__t63 VSS 10.9701025902
* device instance VSS_t64 r0 *1 0,0
RVSS_t64 VSS__t64 VSS 32.8470787364
* device instance VSS_t65 r0 *1 0,0
RVSS_t65 VSS__t65 VSS 13.3971222922
* device instance VSS_t66 r0 *1 0,0
RVSS_t66 VSS__t66 VSS 31.2517242274
* device instance VSS_t67 r0 *1 0,0
RVSS_t67 VSS__t67 VSS 11.1398519041
* device instance VSS_t68 r0 *1 0,0
RVSS_t68 VSS__t68 VSS 11.2572904484
* device instance VSS_t69 r0 *1 0,0
RVSS_t69 VSS__t69 VSS 11.7358241073
* device instance VSS_t70 r0 *1 0,0
RVSS_t70 VSS__t70 VSS 17.5094765144
* device instance VSS_t71 r0 *1 0,0
RVSS_t71 VSS__t71 VSS 19.8044402545
* device instance VSS_t72 r0 *1 0,0
RVSS_t72 VSS__t72 VSS 17.5094765144
* device instance VSS_t73 r0 *1 0,0
RVSS_t73 VSS__t73 VSS 19.8044402545
* device instance VSS_t74 r0 *1 0,0
RVSS_t74 VSS__t74 VSS 10.7420373936
* device instance VSS_t75 r0 *1 0,0
RVSS_t75 VSS__t75 VSS 10.6391134837
* device instance VSS_t76 r0 *1 0,0
RVSS_t76 VSS__t76 VSS 12.9881179569
* device instance VSS_t77 r0 *1 0,0
RVSS_t77 VSS__t77 VSS 14.094998376
* device instance VSS_t78 r0 *1 0,0
RVSS_t78 VSS__t78 VSS 18.1448078253
* device instance VSS_t79 r0 *1 0,0
RVSS_t79 VSS__t79 VSS 17.5094765144
* device instance VSS_t80 r0 *1 0,0
RVSS_t80 VSS__t80 VSS 17.9631868318
* device instance VSS_t81 r0 *1 0,0
RVSS_t81 VSS__t81 VSS 18.4197352432
* device instance VSS_t82 r0 *1 0,0
RVSS_t82 VSS__t82 VSS 18.8789158488
* device instance VSS_t83 r0 *1 0,0
RVSS_t83 VSS__t83 VSS 19.3405411699
* device instance VSS_t84 r0 *1 0,0
RVSS_t84 VSS__t84 VSS 19.8044402545
* device instance VSS_t85 r0 *1 0,0
RVSS_t85 VSS__t85 VSS 18.9146292267
* device instance VSS_t86 r0 *1 0,0
RVSS_t86 VSS__t86 VSS 15.0130039682
* device instance VSS_t87 r0 *1 0,0
RVSS_t87 VSS__t87 VSS 15.6326892074
* device instance VSS_t88 r0 *1 0,0
RVSS_t88 VSS__t88 VSS 14.8155646838
* device instance VSS_t89 r0 *1 0,0
RVSS_t89 VSS__t89 VSS 14.5200851326
* device instance VSS_t90 r0 *1 0,0
RVSS_t90 VSS__t90 VSS 12.9362891387
* device instance VSS_t91 r0 *1 0,0
RVSS_t91 VSS__t91 VSS 12.5689488633
* device instance VSS_t92 r0 *1 0,0
RVSS_t92 VSS__t92 VSS 12.2371587287
* device instance VSS_t93 r0 *1 0,0
RVSS_t93 VSS__t93 VSS 12.2928436123
* device instance VSS_t94 r0 *1 0,0
RVSS_t94 VSS__t94 VSS 11.9056668408
* device instance VSS_t95 r0 *1 0,0
RVSS_t95 VSS__t95 VSS 11.5548466517
* device instance VSS_t96 r0 *1 0,0
RVSS_t96 VSS__t96 VSS 11.2437866727
* device instance VSS_t97 r0 *1 0,0
RVSS_t97 VSS__t97 VSS 11.6627231316
* device instance VSS_t98 r0 *1 0,0
RVSS_t98 VSS__t98 VSS 11.2538886476
* device instance VSS_t99 r0 *1 0,0
RVSS_t99 VSS__t99 VSS 10.8820764523
* device instance VSS_t100 r0 *1 0,0
RVSS_t100 VSS__t100 VSS 13.0647736526
* device instance VSS_t101 r0 *1 0,0
RVSS_t101 VSS__t101 VSS 13.3389594093
* device instance VSS_t102 r0 *1 0,0
RVSS_t102 VSS__t102 VSS 13.6440200053
* device instance VSS_t103 r0 *1 0,0
RVSS_t103 VSS__t103 VSS 13.7224501514
* device instance VSS_t104 r0 *1 0,0
RVSS_t104 VSS__t104 VSS 13.9837464825
* device instance VSS_t105 r0 *1 0,0
RVSS_t105 VSS__t105 VSS 14.2750344822
* device instance VSS_t106 r0 *1 0,0
RVSS_t106 VSS__t106 VSS 14.38453621
* device instance VSS_t107 r0 *1 0,0
RVSS_t107 VSS__t107 VSS 14.6340154949
* device instance VSS_t108 r0 *1 0,0
RVSS_t108 VSS__t108 VSS 14.9126071928
* device instance VSS_t109 r0 *1 0,0
RVSS_t109 VSS__t109 VSS 13.7617539089
* device instance VSS_t110 r0 *1 0,0
RVSS_t110 VSS__t110 VSS 13.7057499348
* device instance VSS_t111 r0 *1 0,0
RVSS_t111 VSS__t111 VSS 13.5523175971
* device instance VSS_t112 r0 *1 0,0
RVSS_t112 VSS__t112 VSS 13.498819105
* device instance VSS_t113 r0 *1 0,0
RVSS_t113 VSS__t113 VSS 14.5038798758
* device instance VSS_t114 r0 *1 0,0
RVSS_t114 VSS__t114 VSS 14.4570547062
* device instance VSS_t115 r0 *1 0,0
RVSS_t115 VSS__t115 VSS 14.4116576867
* device instance VSS_t116 r0 *1 0,0
RVSS_t116 VSS__t116 VSS 14.3677023547
* device instance VSS_t117 r0 *1 0,0
RVSS_t117 VSS__t117 VSS 14.3252019812
* device instance VSS_t118 r0 *1 0,0
RVSS_t118 VSS__t118 VSS 14.2841695533
* device instance VSS_t119 r0 *1 0,0
RVSS_t119 VSS__t119 VSS 14.2446177565
* device instance VSS_t120 r0 *1 0,0
RVSS_t120 VSS__t120 VSS 14.2065589571
* device instance VSS_t121 r0 *1 0,0
RVSS_t121 VSS__t121 VSS 14.1700051853
* device instance VSS_t122 r0 *1 0,0
RVSS_t122 VSS__t122 VSS 14.1349681173
* device instance VSS_t123 r0 *1 0,0
RVSS_t123 VSS__t123 VSS 14.3599636894
* device instance VSS_t124 r0 *1 0,0
RVSS_t124 VSS__t124 VSS 14.3285703486
* device instance VSS_t125 r0 *1 0,0
RVSS_t125 VSS__t125 VSS 14.298700867
* device instance VSS_t126 r0 *1 0,0
RVSS_t126 VSS__t126 VSS 14.2703648135
* device instance VSS_t127 r0 *1 0,0
RVSS_t127 VSS__t127 VSS 14.2435713397
* device instance VSS_t128 r0 *1 0,0
RVSS_t128 VSS__t128 VSS 14.2183291664
* device instance VSS_t129 r0 *1 0,0
RVSS_t129 VSS__t129 VSS 14.1946465695
* device instance VSS_t130 r0 *1 0,0
RVSS_t130 VSS__t130 VSS 14.1725313674
* device instance VSS_t131 r0 *1 0,0
RVSS_t131 VSS__t131 VSS 14.1519909079
* device instance VSS_t132 r0 *1 0,0
RVSS_t132 VSS__t132 VSS 14.1330320573
* device instance VSS_t133 r0 *1 0,0
RVSS_t133 VSS__t133 VSS 14.1156611883
* device instance VSS_t134 r0 *1 0,0
RVSS_t134 VSS__t134 VSS 14.09988417
* device instance VSS_t135 r0 *1 0,0
RVSS_t135 VSS__t135 VSS 14.0857063581
* device instance VSS_t136 r0 *1 0,0
RVSS_t136 VSS__t136 VSS 14.0731325859
* device instance VSS_t137 r0 *1 0,0
RVSS_t137 VSS__t137 VSS 14.0621671562
* device instance VSS_t138 r0 *1 0,0
RVSS_t138 VSS__t138 VSS 14.0528138341
* device instance VSS_t139 r0 *1 0,0
RVSS_t139 VSS__t139 VSS 14.0450758401
* device instance VSS_t140 r0 *1 0,0
RVSS_t140 VSS__t140 VSS 14.0389558454
* device instance VSS_t141 r0 *1 0,0
RVSS_t141 VSS__t141 VSS 14.0344559666
* device instance VSS_t142 r0 *1 0,0
RVSS_t142 VSS__t142 VSS 14.0315777624
* device instance VSS_t143 r0 *1 0,0
RVSS_t143 VSS__t143 VSS 14.0303222308
* device instance VSS_t144 r0 *1 0,0
RVSS_t144 VSS__t144 VSS 14.0306898075
* device instance VSS_t145 r0 *1 0,0
RVSS_t145 VSS__t145 VSS 14.0326803649
* device instance VSS_t146 r0 *1 0,0
RVSS_t146 VSS__t146 VSS 14.0362932126
* device instance VSS_t147 r0 *1 0,0
RVSS_t147 VSS__t147 VSS 14.1503465357
* device instance VSS_t148 r0 *1 0,0
RVSS_t148 VSS__t148 VSS 14.1571469709
* device instance VSS_t149 r0 *1 0,0
RVSS_t149 VSS__t149 VSS 12.7220873656
* device instance VSS_t150 r0 *1 0,0
RVSS_t150 VSS__t150 VSS 12.7332283637
* device instance VSS_t151 r0 *1 0,0
RVSS_t151 VSS__t151 VSS 12.0261535681
* device instance VSS_t152 r0 *1 0,0
RVSS_t152 VSS__t152 VSS 12.0417217049
* device instance VSS_t153 r0 *1 0,0
RVSS_t153 VSS__t153 VSS 11.700251308
* device instance VSS_t154 r0 *1 0,0
RVSS_t154 VSS__t154 VSS 11.7201393761
* device instance VSS_t155 r0 *1 0,0
RVSS_t155 VSS__t155 VSS 11.563042437
* device instance VSS_t156 r0 *1 0,0
RVSS_t156 VSS__t156 VSS 11.5870976122
* device instance VSS_t157 r0 *1 0,0
RVSS_t157 VSS__t157 VSS 11.5242294358
* device instance VSS_t158 r0 *1 0,0
RVSS_t158 VSS__t158 VSS 11.5523088217
* device instance VSS_t159 r0 *1 0,0
RVSS_t159 VSS__t159 VSS 19.5647541138
* device instance VSS_t160 r0 *1 0,0
RVSS_t160 VSS__t160 VSS 25.2154251916
* device instance VSS_t161 r0 *1 0,0
RVSS_t161 VSS__t161 VSS 12.962354262
* device instance VSS_t162 r0 *1 0,0
RVSS_t162 VSS__t162 VSS 5.97346834191
* device instance VSS_t163 r0 *1 0,0
RVSS_t163 VSS__t163 VSS 5.88974384142
* device instance VSS_t164 r0 *1 0,0
RVSS_t164 VSS__t164 VSS 5.73055329037
* device instance VSS_t165 r0 *1 0,0
RVSS_t165 VSS__t165 VSS 5.58315217506
* device instance VSS_t166 r0 *1 0,0
RVSS_t166 VSS__t166 VSS 5.44849741727
* device instance VSS_t167 r0 *1 0,0
RVSS_t167 VSS__t167 VSS 5.32755560289
* device instance VSS_t168 r0 *1 0,0
RVSS_t168 VSS__t168 VSS 5.22127972797
* device instance VSS_t169 r0 *1 0,0
RVSS_t169 VSS__t169 VSS 5.13058125299
* device instance VSS_t170 r0 *1 0,0
RVSS_t170 VSS__t170 VSS 5.80873378441
* device instance VSS_t171 r0 *1 0,0
RVSS_t171 VSS__t171 VSS 5.65531971018
* device instance VSS_t172 r0 *1 0,0
RVSS_t172 VSS__t172 VSS 5.5141710683
* device instance VSS_t173 r0 *1 0,0
RVSS_t173 VSS__t173 VSS 5.38625220505
* device instance VSS_t174 r0 *1 0,0
RVSS_t174 VSS__t174 VSS 5.27252612723
* device instance VSS_t175 r0 *1 0,0
RVSS_t175 VSS__t175 VSS 5.17392881746
* device instance VSS_t176 r0 *1 0,0
RVSS_t176 VSS__t176 VSS 5.09133928881
* device instance VSS_t177 r0 *1 0,0
RVSS_t177 VSS__t177 VSS 5.05629851661
* device instance VSS_t178 r0 *1 0,0
RVSS_t178 VSS__t178 VSS 5.05352459261
* device instance VSS_t179 r0 *1 0,0
RVSS_t179 VSS__t179 VSS 5.033324315
* device instance VSS_t180 r0 *1 0,0
RVSS_t180 VSS__t180 VSS 5.01758345091
* device instance VSS_t181 r0 *1 0,0
RVSS_t181 VSS__t181 VSS 5.00634406415
* device instance VSS_t182 r0 *1 0,0
RVSS_t182 VSS__t182 VSS 6.98465966216
* device instance VSS_t183 r0 *1 0,0
RVSS_t183 VSS__t183 VSS 6.98746246606
* device instance VSS_t184 r0 *1 0,0
RVSS_t184 VSS__t184 VSS 11.1797914745
* device instance VSS_t185 r0 *1 0,0
RVSS_t185 VSS__t185 VSS 11.1883297435
* device instance VSS_t186 r0 *1 0,0
RVSS_t186 VSS__t186 VSS 19.1725636954
* device instance VSS_t187 r0 *1 0,0
RVSS_t187 VSS__t187 VSS 18.9146292267
* device instance VSS_t188 r0 *1 0,0
RVSS_t188 VSS__t188 VSS 15.6326892074
* device instance VSS_t189 r0 *1 0,0
RVSS_t189 VSS__t189 VSS 15.0130039682
* device instance VSS_t190 r0 *1 0,0
RVSS_t190 VSS__t190 VSS 14.8155646838
* device instance VSS_t191 r0 *1 0,0
RVSS_t191 VSS__t191 VSS 14.5200851326
* device instance VSS_t192 r0 *1 0,0
RVSS_t192 VSS__t192 VSS 18.5496443538
* device instance VSS_t193 r0 *1 0,0
RVSS_t193 VSS__t193 VSS 18.1448078253
* device instance VSS_t194 r0 *1 0,0
RVSS_t194 VSS__t194 VSS 19.8044402545
* device instance VSS_t195 r0 *1 0,0
RVSS_t195 VSS__t195 VSS 19.3405411699
* device instance VSS_t196 r0 *1 0,0
RVSS_t196 VSS__t196 VSS 18.8789158488
* device instance VSS_t197 r0 *1 0,0
RVSS_t197 VSS__t197 VSS 18.4197352432
* device instance VSS_t198 r0 *1 0,0
RVSS_t198 VSS__t198 VSS 17.9631868318
* device instance VSS_t199 r0 *1 0,0
RVSS_t199 VSS__t199 VSS 17.5094765144
* device instance VSS_t200 r0 *1 0,0
RVSS_t200 VSS__t200 VSS 17.6792311862
* device instance VSS_t201 r0 *1 0,0
RVSS_t201 VSS__t201 VSS 14.094998376
* device instance VSS_t202 r0 *1 0,0
RVSS_t202 VSS__t202 VSS 17.4079544758
* device instance VSS_t203 r0 *1 0,0
RVSS_t203 VSS__t203 VSS 17.026083458
* device instance VSS_t204 r0 *1 0,0
RVSS_t204 VSS__t204 VSS 16.6525309784
* device instance VSS_t205 r0 *1 0,0
RVSS_t205 VSS__t205 VSS 16.2878693888
* device instance VSS_t206 r0 *1 0,0
RVSS_t206 VSS__t206 VSS 15.9327091746
* device instance VSS_t207 r0 *1 0,0
RVSS_t207 VSS__t207 VSS 15.3047177725
* device instance VSS_t208 r0 *1 0,0
RVSS_t208 VSS__t208 VSS 15.2349536978
* device instance VSS_t209 r0 *1 0,0
RVSS_t209 VSS__t209 VSS 14.6663253377
* device instance VSS_t210 r0 *1 0,0
RVSS_t210 VSS__t210 VSS 12.3883406075
* device instance VSS_t211 r0 *1 0,0
RVSS_t211 VSS__t211 VSS 12.4351506301
* device instance VSS_t212 r0 *1 0,0
RVSS_t212 VSS__t212 VSS 12.9881179569
* device instance VSS_t213 r0 *1 0,0
RVSS_t213 VSS__t213 VSS 10.7420373936
* device instance VSS_t214 r0 *1 0,0
RVSS_t214 VSS__t214 VSS 10.6391134837
* device instance VSS_t215 r0 *1 0,0
RVSS_t215 VSS__t215 VSS 14.3419763563
* device instance VSS_t216 r0 *1 0,0
RVSS_t216 VSS__t216 VSS 12.5734242329
* device instance VSS_t217 r0 *1 0,0
RVSS_t217 VSS__t217 VSS 12.6838927664
* device instance VSS_t218 r0 *1 0,0
RVSS_t218 VSS__t218 VSS 11.7358241073
* device instance VSS_t219 r0 *1 0,0
RVSS_t219 VSS__t219 VSS 11.2572904484
* device instance VSS_t220 r0 *1 0,0
RVSS_t220 VSS__t220 VSS 12.7484030229
* device instance VSS_t221 r0 *1 0,0
RVSS_t221 VSS__t221 VSS 12.802239454
* device instance VSS_t222 r0 *1 0,0
RVSS_t222 VSS__t222 VSS 31.2517242274
* device instance VSS_t223 r0 *1 0,0
RVSS_t223 VSS__t223 VSS 32.7019481989
* device instance VSS_t224 r0 *1 0,0
RVSS_t224 VSS__t224 VSS 32.8470787364
* device instance VSS_t225 r0 *1 0,0
RVSS_t225 VSS__t225 VSS 13.5020333939
* device instance VSS_t226 r0 *1 0,0
RVSS_t226 VSS__t226 VSS 13.3971222922
* device instance VSS_t227 r0 *1 0,0
RVSS_t227 VSS__t227 VSS 11.1398519041
* device instance VSS_t228 r0 *1 0,0
RVSS_t228 VSS__t228 VSS 12.8857380219
* device instance VSS_t229 r0 *1 0,0
RVSS_t229 VSS__t229 VSS 31.6309498602
* device instance VSS_t230 r0 *1 0,0
RVSS_t230 VSS__t230 VSS 32.3862625376
* device instance VSS_t231 r0 *1 0,0
RVSS_t231 VSS__t231 VSS 32.5545001769
* device instance VSS_t232 r0 *1 0,0
RVSS_t232 VSS__t232 VSS 10.9701025902
* device instance VSS_t233 r0 *1 0,0
RVSS_t233 VSS__t233 VSS 10.8648631224
* device instance VSS_t234 r0 *1 0,0
RVSS_t234 VSS__t234 VSS 12.7378189321
* device instance VSS_t235 r0 *1 0,0
RVSS_t235 VSS__t235 VSS 38.20460511
* device instance VSS_t236 r0 *1 0,0
RVSS_t236 VSS__t236 VSS 13.0769454302
* device instance VSS_t237 r0 *1 0,0
RVSS_t237 VSS__t237 VSS 13.1392890586
* device instance VSS_t238 r0 *1 0,0
RVSS_t238 VSS__t238 VSS 31.1174773054
* device instance VSS_t239 r0 *1 0,0
RVSS_t239 VSS__t239 VSS 12.2544548492
* device instance VSS_t240 r0 *1 0,0
RVSS_t240 VSS__t240 VSS 13.3029489567
* device instance VSS_t241 r0 *1 0,0
RVSS_t241 VSS__t241 VSS 28.4326543923
* device instance VSS_t242 r0 *1 0,0
RVSS_t242 VSS__t242 VSS 29.2516424815
* device instance VSS_t243 r0 *1 0,0
RVSS_t243 VSS__t243 VSS 30.1611595813
* device instance VSS_t244 r0 *1 0,0
RVSS_t244 VSS__t244 VSS 30.6658704726
* device instance VSS_t245 r0 *1 0,0
RVSS_t245 VSS__t245 VSS 31.4450703782
* device instance VSS_t246 r0 *1 0,0
RVSS_t246 VSS__t246 VSS 32.0129633638
* device instance VSS_t247 r0 *1 0,0
RVSS_t247 VSS__t247 VSS 13.6083051134
* device instance VSS_t248 r0 *1 0,0
RVSS_t248 VSS__t248 VSS 13.2322265468
* device instance VSS_t249 r0 *1 0,0
RVSS_t249 VSS__t249 VSS 12.8266953617
* device instance VSS_t250 r0 *1 0,0
RVSS_t250 VSS__t250 VSS 11.5696809269
* device instance VSS_t251 r0 *1 0,0
RVSS_t251 VSS__t251 VSS 9.98299952275
* device instance VSS_t252 r0 *1 0,0
RVSS_t252 VSS__t252 VSS 9.89391678895
* device instance VSS_t253 r0 *1 0,0
RVSS_t253 VSS__t253 VSS 9.80576923915
* device instance VSS_t254 r0 *1 0,0
RVSS_t254 VSS__t254 VSS 9.71858231973
* device instance VSS_t255 r0 *1 0,0
RVSS_t255 VSS__t255 VSS 9.63238211599
* device instance VSS_t256 r0 *1 0,0
RVSS_t256 VSS__t256 VSS 9.5471953547
* device instance VSS r0 *1 0,0
CVSS VSS vsubs 2.188762023e-12
* device instance cc__13__6 r0 *1 0,0
Ccc__13__6 \$13 \$6 1.1805e-17
* device instance cc__18__6 r0 *1 0,0
Ccc__18__6 \$18 \$6 1.1805e-17
* device instance cc__25__27 r0 *1 0,0
Ccc__25__27 \$25 \$27 1.8889e-17
* device instance cc__25_BIAS_OK r0 *1 0,0
Ccc__25_BIAS_OK \$25 BIAS_OK 9.444e-18
* device instance cc__25_BIAS_OKB r0 *1 0,0
Ccc__25_BIAS_OKB \$25 BIAS_OKB 9.444e-18
* device instance cc__25_VDD r0 *1 0,0
Ccc__25_VDD \$25 VDD 9.444e-18
* device instance cc__27_VDD r0 *1 0,0
Ccc__27_VDD \$27 VDD 9.444e-18
* device instance cc__31__47 r0 *1 0,0
Ccc__31__47 \$31 \$47 4.7222e-17
* device instance cc__32__47 r0 *1 0,0
Ccc__32__47 \$32 \$47 4.7222e-17
* device instance cc__33__47 r0 *1 0,0
Ccc__33__47 \$33 \$47 4.7222e-17
* device instance cc__33__48 r0 *1 0,0
Ccc__33__48 \$33 \$48 4.7222e-17
* device instance cc__34__47 r0 *1 0,0
Ccc__34__47 \$34 \$47 2.3611e-17
* device instance cc__34__48 r0 *1 0,0
Ccc__34__48 \$34 \$48 2.3611e-17
* device instance cc__36__47 r0 *1 0,0
Ccc__36__47 \$36 \$47 2.3611e-17
* device instance cc__37__47 r0 *1 0,0
Ccc__37__47 \$37 \$47 7.0832e-17
* device instance cc__37__48 r0 *1 0,0
Ccc__37__48 \$37 \$48 7.0832e-17
* device instance cc__40__45 r0 *1 0,0
Ccc__40__45 \$40 \$45 1.4757e-17
* device instance cc__40__6 r0 *1 0,0
Ccc__40__6 \$40 \$6 1.4757e-17
* device instance cc__40_VDD r0 *1 0,0
Ccc__40_VDD \$40 VDD 7.7718e-17
* device instance cc__45__6 r0 *1 0,0
Ccc__45__6 \$45 \$6 2.30203e-16
* device instance cc__46__6 r0 *1 0,0
Ccc__46__6 \$46 \$6 1.5347e-16
* device instance cc__47__48 r0 *1 0,0
Ccc__47__48 \$47 \$48 5.0173e-17
* device instance cc__47__49 r0 *1 0,0
Ccc__47__49 \$47 \$49 4.7222e-17
* device instance cc__47_EN_RESETn r0 *1 0,0
Ccc__47_EN_RESETn \$47 EN|RESETn 6.0208e-17
* device instance cc__47_VDD r0 *1 0,0
Ccc__47_VDD \$47 VDD 1.5347e-16
* device instance cc__47_VSS r0 *1 0,0
Ccc__47_VSS \$47 VSS 3.269281e-15
* device instance cc__48__49 r0 *1 0,0
Ccc__48__49 \$48 \$49 4.7222e-17
* device instance cc__48_EN_RESETn r0 *1 0,0
Ccc__48_EN_RESETn \$48 EN|RESETn 6.0208e-17
* device instance cc__48_VDD r0 *1 0,0
Ccc__48_VDD \$48 VDD 1.5347e-16
* device instance cc__48_VSS r0 *1 0,0
Ccc__48_VSS \$48 VSS 7.8531938e-14
* device instance cc__59__6 r0 *1 0,0
Ccc__59__6 \$59 \$6 1.1805e-17
* device instance cc__6__7 r0 *1 0,0
Ccc__6__7 \$6 \$7 1.1805e-17
* device instance cc__6_VREF r0 *1 0,0
Ccc__6_VREF \$6 VREF 1.1805e-17
* device instance cc__6_VSS r0 *1 0,0
Ccc__6_VSS \$6 VSS 3.5416e-17
* device instance cc_BIAS_OK_IBIAS r0 *1 0,0
Ccc_BIAS_OK_IBIAS BIAS_OK IBIAS 1.1428e-17
* device instance cc_BIAS_OK_POR_RAW r0 *1 0,0
Ccc_BIAS_OK_POR_RAW BIAS_OK POR_RAW 1.1428e-17
* device instance cc_BIAS_OK_VDD r0 *1 0,0
Ccc_BIAS_OK_VDD BIAS_OK VDD 2.2855e-17
* device instance cc_BIAS_OK_VREF r0 *1 0,0
Ccc_BIAS_OK_VREF BIAS_OK VREF 1.1428e-17
* device instance cc_BIAS_OK_VSS r0 *1 0,0
Ccc_BIAS_OK_VSS BIAS_OK VSS 3.4283e-17
* device instance cc_CTAT_NA r0 *1 0,0
Ccc_CTAT_NA CTAT NA 8.311e-18
* device instance cc_CTAT_NB r0 *1 0,0
Ccc_CTAT_NB CTAT NB 8.311e-18
* device instance cc_CTAT_NC r0 *1 0,0
Ccc_CTAT_NC CTAT NC 8.311e-18
* device instance cc_CTAT_NT r0 *1 0,0
Ccc_CTAT_NT CTAT NT 8.311e-18
* device instance cc_CTAT_NZ r0 *1 0,0
Ccc_CTAT_NZ CTAT NZ 8.311e-18
* device instance cc_CTAT_PTAT r0 *1 0,0
Ccc_CTAT_PTAT CTAT PTAT 8.311e-18
* device instance cc_CTAT_T0 r0 *1 0,0
Ccc_CTAT_T0 CTAT T0 8.311e-18
* device instance cc_CTAT_T1 r0 *1 0,0
Ccc_CTAT_T1 CTAT T1 8.311e-18
* device instance cc_CTAT_T2 r0 *1 0,0
Ccc_CTAT_T2 CTAT T2 8.311e-18
* device instance cc_CTAT_T3 r0 *1 0,0
Ccc_CTAT_T3 CTAT T3 8.311e-18
* device instance cc_CTAT_T4 r0 *1 0,0
Ccc_CTAT_T4 CTAT T4 8.311e-18
* device instance cc_CTAT_T5 r0 *1 0,0
Ccc_CTAT_T5 CTAT T5 8.311e-18
* device instance cc_CTAT_VDD r0 *1 0,0
Ccc_CTAT_VDD CTAT VDD 9.7654e-17
* device instance cc_EN_RESETn_IBIAS r0 *1 0,0
Ccc_EN_RESETn_IBIAS EN|RESETn IBIAS 3.4283e-17
* device instance cc_EN_RESETn_VDD r0 *1 0,0
Ccc_EN_RESETn_VDD EN|RESETn VDD 1.2051e-16
* device instance cc_EN_RESETn_VREF r0 *1 0,0
Ccc_EN_RESETn_VREF EN|RESETn VREF 2.2855e-17
* device instance cc_EN_RESETn_VSS r0 *1 0,0
Ccc_EN_RESETn_VSS EN|RESETn VSS 7.0903e-17
* device instance cc_ENB_VDD r0 *1 0,0
Ccc_ENB_VDD ENB VDD 7.4799e-17
* device instance cc_IBIAS_POR_RAW r0 *1 0,0
Ccc_IBIAS_POR_RAW IBIAS POR_RAW 2.2855e-17
* device instance cc_IBIAS_VDD r0 *1 0,0
Ccc_IBIAS_VDD IBIAS VDD 5.9216e-17
* device instance cc_IBIAS_VREF r0 *1 0,0
Ccc_IBIAS_VREF IBIAS VREF 1.1428e-17
* device instance cc_IBIAS_VSS r0 *1 0,0
Ccc_IBIAS_VSS IBIAS VSS 4.5711e-17
* device instance cc_M1D_NT r0 *1 0,0
Ccc_M1D_NT M1D NT 8.311e-18
* device instance cc_M1D_VDD r0 *1 0,0
Ccc_M1D_VDD M1D VDD 1.6622e-17
* device instance cc_M2D_NT r0 *1 0,0
Ccc_M2D_NT M2D NT 8.311e-18
* device instance cc_M2D_VDD r0 *1 0,0
Ccc_M2D_VDD M2D VDD 1.6622e-17
* device instance cc_M3D_NT r0 *1 0,0
Ccc_M3D_NT M3D NT 8.311e-18
* device instance cc_M3D_VDD r0 *1 0,0
Ccc_M3D_VDD M3D VDD 1.6622e-17
* device instance cc_N1_NT r0 *1 0,0
Ccc_N1_NT N1 NT 8.311e-18
* device instance cc_N1_VDD r0 *1 0,0
Ccc_N1_VDD N1 VDD 8.311e-18
* device instance cc_N2_NA r0 *1 0,0
Ccc_N2_NA N2 NA 8.311e-18
* device instance cc_N2_NB r0 *1 0,0
Ccc_N2_NB N2 NB 8.311e-18
* device instance cc_N2_NC r0 *1 0,0
Ccc_N2_NC N2 NC 8.311e-18
* device instance cc_N2_NT r0 *1 0,0
Ccc_N2_NT N2 NT 8.311e-18
* device instance cc_N2_PTAT r0 *1 0,0
Ccc_N2_PTAT N2 PTAT 8.311e-18
* device instance cc_N2_T0 r0 *1 0,0
Ccc_N2_T0 N2 T0 8.311e-18
* device instance cc_N2_T1 r0 *1 0,0
Ccc_N2_T1 N2 T1 8.311e-18
* device instance cc_N2_T2 r0 *1 0,0
Ccc_N2_T2 N2 T2 8.311e-18
* device instance cc_N2_T3 r0 *1 0,0
Ccc_N2_T3 N2 T3 8.311e-18
* device instance cc_N2_T4 r0 *1 0,0
Ccc_N2_T4 N2 T4 8.311e-18
* device instance cc_N2_T5 r0 *1 0,0
Ccc_N2_T5 N2 T5 8.311e-18
* device instance cc_N2_VDD r0 *1 0,0
Ccc_N2_VDD N2 VDD 7.4799e-17
* device instance cc_NA_NC r0 *1 0,0
Ccc_NA_NC NA NC 1.6622e-17
* device instance cc_NA_NT r0 *1 0,0
Ccc_NA_NT NA NT 8.311e-18
* device instance cc_NA_NZ r0 *1 0,0
Ccc_NA_NZ NA NZ 8.311e-18
* device instance cc_NA_PTAT r0 *1 0,0
Ccc_NA_PTAT NA PTAT 8.311e-18
* device instance cc_NA_T0 r0 *1 0,0
Ccc_NA_T0 NA T0 8.311e-18
* device instance cc_NA_T1 r0 *1 0,0
Ccc_NA_T1 NA T1 8.311e-18
* device instance cc_NA_T2 r0 *1 0,0
Ccc_NA_T2 NA T2 8.311e-18
* device instance cc_NA_T3 r0 *1 0,0
Ccc_NA_T3 NA T3 8.311e-18
* device instance cc_NA_T4 r0 *1 0,0
Ccc_NA_T4 NA T4 8.311e-18
* device instance cc_NA_T5 r0 *1 0,0
Ccc_NA_T5 NA T5 8.311e-18
* device instance cc_NA_VDD r0 *1 0,0
Ccc_NA_VDD NA VDD 7.4799e-17
* device instance cc_NA_VSS r0 *1 0,0
Ccc_NA_VSS NA VSS 1.32976e-16
* device instance cc_NB_NC r0 *1 0,0
Ccc_NB_NC NB NC 8.311e-18
* device instance cc_NB_NT r0 *1 0,0
Ccc_NB_NT NB NT 8.311e-18
* device instance cc_NB_NZ r0 *1 0,0
Ccc_NB_NZ NB NZ 8.311e-18
* device instance cc_NB_PTAT r0 *1 0,0
Ccc_NB_PTAT NB PTAT 8.311e-18
* device instance cc_NB_T0 r0 *1 0,0
Ccc_NB_T0 NB T0 8.311e-18
* device instance cc_NB_T1 r0 *1 0,0
Ccc_NB_T1 NB T1 8.311e-18
* device instance cc_NB_T2 r0 *1 0,0
Ccc_NB_T2 NB T2 8.311e-18
* device instance cc_NB_T3 r0 *1 0,0
Ccc_NB_T3 NB T3 8.311e-18
* device instance cc_NB_T4 r0 *1 0,0
Ccc_NB_T4 NB T4 8.311e-18
* device instance cc_NB_T5 r0 *1 0,0
Ccc_NB_T5 NB T5 8.311e-18
* device instance cc_NB_VDD r0 *1 0,0
Ccc_NB_VDD NB VDD 7.4799e-17
* device instance cc_NBG_VDD r0 *1 0,0
Ccc_NBG_VDD NBG VDD 3.3244e-17
* device instance cc_NC_NT r0 *1 0,0
Ccc_NC_NT NC NT 8.311e-18
* device instance cc_NC_NZ r0 *1 0,0
Ccc_NC_NZ NC NZ 8.311e-18
* device instance cc_NC_PTAT r0 *1 0,0
Ccc_NC_PTAT NC PTAT 8.311e-18
* device instance cc_NC_T0 r0 *1 0,0
Ccc_NC_T0 NC T0 1.6622e-17
* device instance cc_NC_T1 r0 *1 0,0
Ccc_NC_T1 NC T1 1.6622e-17
* device instance cc_NC_T2 r0 *1 0,0
Ccc_NC_T2 NC T2 1.6622e-17
* device instance cc_NC_T3 r0 *1 0,0
Ccc_NC_T3 NC T3 1.6622e-17
* device instance cc_NC_T4 r0 *1 0,0
Ccc_NC_T4 NC T4 1.6622e-17
* device instance cc_NC_T5 r0 *1 0,0
Ccc_NC_T5 NC T5 1.6622e-17
* device instance cc_NC_VDD r0 *1 0,0
Ccc_NC_VDD NC VDD 7.4799e-17
* device instance cc_NC_VSS r0 *1 0,0
Ccc_NC_VSS NC VSS 2.65952e-16
* device instance cc_ND_NT r0 *1 0,0
Ccc_ND_NT ND NT 8.311e-18
* device instance cc_ND_VDD r0 *1 0,0
Ccc_ND_VDD ND VDD 6.6488e-17
* device instance cc_NR_NT r0 *1 0,0
Ccc_NR_NT NR NT 8.311e-18
* device instance cc_NR_VDD r0 *1 0,0
Ccc_NR_VDD NR VDD 6.6488e-17
* device instance cc_NT_NZ r0 *1 0,0
Ccc_NT_NZ NT NZ 8.311e-18
* device instance cc_NT_PG r0 *1 0,0
Ccc_NT_PG NT PG 8.311e-18
* device instance cc_NT_PTAT r0 *1 0,0
Ccc_NT_PTAT NT PTAT 8.311e-18
* device instance cc_NT_T0 r0 *1 0,0
Ccc_NT_T0 NT T0 8.311e-18
* device instance cc_NT_T1 r0 *1 0,0
Ccc_NT_T1 NT T1 8.311e-18
* device instance cc_NT_T2 r0 *1 0,0
Ccc_NT_T2 NT T2 8.311e-18
* device instance cc_NT_T3 r0 *1 0,0
Ccc_NT_T3 NT T3 8.311e-18
* device instance cc_NT_T4 r0 *1 0,0
Ccc_NT_T4 NT T4 8.311e-18
* device instance cc_NT_T5 r0 *1 0,0
Ccc_NT_T5 NT T5 8.311e-18
* device instance cc_NT_VDD r0 *1 0,0
Ccc_NT_VDD NT VDD 7.4799e-17
* device instance cc_NZ_PG r0 *1 0,0
Ccc_NZ_PG NZ PG 1.36745e-16
* device instance cc_NZ_VDD r0 *1 0,0
Ccc_NZ_VDD NZ VDD 7.4799e-17
* device instance cc_PB_VDD r0 *1 0,0
Ccc_PB_VDD PB VDD 5.8177e-17
* device instance cc_PCAS_VDD r0 *1 0,0
Ccc_PCAS_VDD PCAS VDD 4.1555e-17
* device instance cc_PG_VDD r0 *1 0,0
Ccc_PG_VDD PG VDD 7.4799e-17
* device instance cc_POR_RAW_VDD r0 *1 0,0
Ccc_POR_RAW_VDD POR_RAW VDD 1.1428e-17
* device instance cc_POR_RAW_VREF r0 *1 0,0
Ccc_POR_RAW_VREF POR_RAW VREF 1.1428e-17
* device instance cc_POR_RAW_VSS r0 *1 0,0
Ccc_POR_RAW_VSS POR_RAW VSS 2.2855e-17
* device instance cc_PTAT_T0 r0 *1 0,0
Ccc_PTAT_T0 PTAT T0 8.311e-18
* device instance cc_PTAT_T1 r0 *1 0,0
Ccc_PTAT_T1 PTAT T1 8.311e-18
* device instance cc_PTAT_T2 r0 *1 0,0
Ccc_PTAT_T2 PTAT T2 8.311e-18
* device instance cc_PTAT_T3 r0 *1 0,0
Ccc_PTAT_T3 PTAT T3 8.311e-18
* device instance cc_PTAT_T4 r0 *1 0,0
Ccc_PTAT_T4 PTAT T4 8.311e-18
* device instance cc_PTAT_T5 r0 *1 0,0
Ccc_PTAT_T5 PTAT T5 8.311e-18
* device instance cc_PTAT_VDD r0 *1 0,0
Ccc_PTAT_VDD PTAT VDD 9.7654e-17
* device instance cc_T0_T1 r0 *1 0,0
Ccc_T0_T1 T0 T1 1.6622e-17
* device instance cc_T0_T2 r0 *1 0,0
Ccc_T0_T2 T0 T2 1.6622e-17
* device instance cc_T0_T3 r0 *1 0,0
Ccc_T0_T3 T0 T3 1.6622e-17
* device instance cc_T0_T4 r0 *1 0,0
Ccc_T0_T4 T0 T4 1.6622e-17
* device instance cc_T0_T5 r0 *1 0,0
Ccc_T0_T5 T0 T5 1.6622e-17
* device instance cc_T0_VDD r0 *1 0,0
Ccc_T0_VDD T0 VDD 7.4799e-17
* device instance cc_T1_T2 r0 *1 0,0
Ccc_T1_T2 T1 T2 1.6622e-17
* device instance cc_T1_T3 r0 *1 0,0
Ccc_T1_T3 T1 T3 1.6622e-17
* device instance cc_T1_T4 r0 *1 0,0
Ccc_T1_T4 T1 T4 1.6622e-17
* device instance cc_T1_T5 r0 *1 0,0
Ccc_T1_T5 T1 T5 1.6622e-17
* device instance cc_T1_VDD r0 *1 0,0
Ccc_T1_VDD T1 VDD 7.4799e-17
* device instance cc_T2_T3 r0 *1 0,0
Ccc_T2_T3 T2 T3 1.6622e-17
* device instance cc_T2_T4 r0 *1 0,0
Ccc_T2_T4 T2 T4 1.6622e-17
* device instance cc_T2_T5 r0 *1 0,0
Ccc_T2_T5 T2 T5 1.6622e-17
* device instance cc_T2_VDD r0 *1 0,0
Ccc_T2_VDD T2 VDD 7.4799e-17
* device instance cc_T3_T4 r0 *1 0,0
Ccc_T3_T4 T3 T4 1.6622e-17
* device instance cc_T3_T5 r0 *1 0,0
Ccc_T3_T5 T3 T5 1.6622e-17
* device instance cc_T3_VDD r0 *1 0,0
Ccc_T3_VDD T3 VDD 7.4799e-17
* device instance cc_T4_T5 r0 *1 0,0
Ccc_T4_T5 T4 T5 1.6622e-17
* device instance cc_T4_VDD r0 *1 0,0
Ccc_T4_VDD T4 VDD 7.4799e-17
* device instance cc_T5_VDD r0 *1 0,0
Ccc_T5_VDD T5 VDD 7.4799e-17
* device instance cc_VDD_VREF r0 *1 0,0
Ccc_VDD_VREF VDD VREF 1.1428e-17
* device instance cc_VDD_VSS r0 *1 0,0
Ccc_VDD_VSS VDD VSS 9.1421e-17
* device instance cc_VREF_VSS r0 *1 0,0
Ccc_VREF_VSS VREF VSS 2.2855e-17
* device instance vsubs_dctie r0 *1 0,0
Rvsubs_dctie vsubs 0 1e+12
.ENDS temp_por_top
