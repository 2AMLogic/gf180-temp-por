* tb_por_comparator_postlayout -- GENERATED by sim/build_tb.py
* Do not edit. Sources:
*   sim/por-comparator-designer-check/testbench/stimulus.spice
*   layout/postlayout/por_comparator.spice  (sha256 7f18f5adb295c1be56e6edfd1af6ad355c538bb78a4a2f56efe4aa786d864299)
* Regenerate with:
*   python3 sim/build_tb.py

* por-comparator-designer-check -- stimulus half of the testbench fragment.
*
* The other half is a verbatim copy of design/netlist/por_comparator.spice,
* appended by sim/build_tb.py to produce tb_por_comparator.spice. Edit THIS
* file (or the schematic), never the generated fragment.
*
* Netlist FRAGMENT: no .include / .lib / .temp / .control / .end -- the
* harness owns those. Parameters it supplies: vdd_val, vdd_nom, temp_c, plus
* `dvdd_dt_v_per_s` from ../testbench/tb.json's `params` map (issue #206).
*
* RAMP RATE: dVDD/dt CONSTANT ACROSS THE SUPPLY AXIS (issue #206). Both ramp
* branches (1, 2 below) used to traverse 0 -> vdd_val (or the reverse) in a
* FIXED 10 ms, so dVDD/dt was itself a function of vdd_val -- 297 / 330 /
* 363 V/s at 2.97 / 3.30 / 3.63 V -- the same shape of confound
* sim/por-vth/'s stimulus had, with a smaller coefficient because VREF here
* is an idealised fixed 1.2 V source (zero output impedance, so it cannot be
* displaced by the moving rail the way bias_core's real reference is -- see
* sim/por-vth/control/results.md). The duration is now DERIVED from a
* constant `dvdd_dt_v_per_s` (../testbench/tb.json's `params`):
* `tramp = vdd_val / dvdd_dt_v_per_s`. The chosen rate, 297 V/s, is not a new
* number -- it is this deck's own 2.97 V corner's native rate under the old
* fixed-10-ms scheme, so that corner's reading is bit-for-bit unchanged by
* this fix, matching the reuse-the-slowest-native-rate choice
* sim/por-vth/testbench/stimulus.spice makes for the same reason.
*
* bias_core (issue #11) is still a placeholder, so IBIAS and VREF are
* idealised fixed stimuli here, exactly like temp-core-designer-check does
* for IBIAS: 500 nA into IBIAS, 1.2 V (bandgap-scale, per
* sim/devchar/SUMMARY.md's "comparator input pair" note) into VREF. This is
* the comparator's OWN intrinsic threshold characteristic, independent of
* #11's real startup-ordering timing -- the more realistic ramped-together
* bring-up (BIAS_OK arriving after VREF settles, per DR-005 startup step 4)
* is #14's job, matching temp-core-startup's precedent for the analogous
* split.
*
* Five independent branches:
*
*   1/2. xup / xdn  a VDD 0->vdd_val ramp and a vdd_val->0 ramp, run in the
*        SAME transient so both edges of one hysteresis pair are measured
*        at the same corner point (spec/target-spec.md#por-hysteresis).
*        BIAS_OK is tied high throughout each ramp (including down to 0 V)
*        so the sweep captures the comparator's own threshold characteristic
*        over the full range, including below its own operating floor --
*        see the Test Plan's edge-case bullet. VREF/IBIAS ride the block's
*        own separately-referenced idealised sources.
*   3. xiq   a static enabled DUT at this point's vdd_val, for the settled
*        (released) Iq reading, IBIAS sourced from the measured rail so the
*        reading is DR-007 rule 1's conservative number.
*   4. xiqdis  a static DUT at this point's vdd_val with BIAS_OK held low
*        throughout, for the pre-bias-core-valid Iq reading. This is also the
*        divider's worst-case (RHYS shorted) configuration at full rail.
*   5. xiqown  the same enabled DUT as branch 3 but with IBIAS sourced from a
*        SEPARATE rail, so vsupown measures the cell's OWN draw with the
*        shared reference current excluded. iq_run_ua - iq_own_ua is the
*        reference current by construction, which is what #11 needs to see.
*
* The rising and falling ramps use two DUT instances rather than one ramp with
* a fold-back, so each edge is measured on a monotonic sweep with a settled
* history. sw_stat_mismatch=0 in design.ngspice, so the two instances are
* electrically identical and "same corner point" is exact, not approximate --
* mismatch between them is #15's Monte Carlo job.
*
* Absolute-temperature probe not needed here (no temperature-dependent
* transfer function is being extracted, only threshold voltages and Iq).

.param tramp='vdd_val/dvdd_dt_v_per_s'

* ---- 1. rising ramp: VPOR-uparrow -------------------------------------
vsupup vddup 0 pwl(0 0 {tramp} {vdd_val})
vokup bias_okup 0 dc {vdd_val}
vrefup vrefup 0 dc 1.2
ibrefup vddup ibiasup dc 500n
xup vddup 0 ibiasup vrefup bias_okup por_rawup por_comparator

* ---- 1b. rising ramp with VREF deliberately 5 % high --------------------
* Identical to branch 1 except VREF = 1.26 V instead of 1.20 V. The whole
* threshold is VREF times a resistor ratio, so this branch MEASURES the
* fractional sensitivity d(VPOR)/VPOR per d(VREF)/VREF instead of leaving it
* as algebra -- which is the number bias_core (#11) has to design its
* reference accuracy against, since this cell spends almost none of the
* ratified +/-5 % window itself.
vsupur vddur 0 pwl(0 0 {tramp} {vdd_val})
vokur bias_okur 0 dc {vdd_val}
vrefur vrefur 0 dc 1.26
ibrefur vddur ibiasur dc 500n
xupr vddur 0 ibiasur vrefur bias_okur por_rawur por_comparator

* ---- 2. falling ramp: VPOR-downarrow, same corner point ----------------
vsupdn vdddn 0 pwl(0 {vdd_val} {tramp} 0)
vokdn bias_okdn 0 dc {vdd_val}
vrefdn vrefdn 0 dc 1.2
ibrefdn vdddn ibiasdn dc 500n
xdn vdddn 0 ibiasdn vrefdn bias_okdn por_rawdn por_comparator

* ---- 3. enabled DUT, settled at this point's vdd_val --------------------
vsupiq vddiq 0 dc {vdd_val}
vokiq bias_okiq 0 dc {vdd_val}
vrefiq vrefiq 0 dc 1.2
ibrefiq vddiq ibiasiq dc 500n
xiq vddiq 0 ibiasiq vrefiq bias_okiq por_rawiq por_comparator

* ---- 4. disabled DUT (BIAS_OK low), settled at this point's vdd_val -----
vsupdis vdddis 0 dc {vdd_val}
vokdis bias_okdis 0 dc 0
vrefdis vrefdis 0 dc 1.2
ibrefdis vdddis ibiasdis dc 500n
xiqdis vdddis 0 ibiasdis vrefdis bias_okdis por_rawdis por_comparator

* ---- 5. enabled DUT, IBIAS referenced to its OWN separate rail -----------
* Same operating point as branch 3; the only difference is that the 500 nA
* reference is pushed in from vbrown, not from the rail vsupown measures. So
* iq_own_ua is por_comparator's own consumption and iq_run_ua - iq_own_ua is
* exactly the reference current, with no arithmetic across PVT points.
vsupown vddown 0 dc {vdd_val}
vokown bias_okown 0 dc {vdd_val}
vrefown vrefown 0 dc 1.2
vbown vbrown 0 dc {vdd_val}
ibrefown vbrown ibiasown dc 500n
xiqown vddown 0 ibiasown vrefown bias_okown por_rawown por_comparator

* por_comparator -- post-layout netlist
* GENERATED by layout/postlayout.py -- do not edit.
*
* FROM THE LAYOUT: every device and its dimensions, the whole
*   topology, and first-order interconnect R/C on 15/15 nets
*   (sigma 526.8 fF, of which 0.057 fF is net-to-net coupling).
*   One star per net: <net> is the hub, <net>__t<k> each device
*   terminal on it, R<net>_t<k> the arm between them.
*   klt 0.6.0, deck gf180mcu,
*   GDS sha256 e6e5601250e6c78e...
* Net names are the schematic's, restored through klt lvs's own net
*   correspondence -- match, 15/15 nets, every one paired.
*
* NOT FROM THE LAYOUT -- see layout/postlayout/AUDIT.md:
*   3 body/plate net(s) tied to the net the schematic puts
*   them on. The extraction deck's connectivity stack does not reach
*   an Nwell, a substrate ring, a bipolar base well or a MiM plate,
*   so they extract isolated and would otherwise float.
*   No ideal device: every golden device is drawn.
*
.subckt por_comparator VDD VSS IBIAS VREF BIAS_OK POR_RAW

* --- drawn devices ---
X1 TN__t1 NBG__t0 VSS__t2 VSS__t13 nfet_03v3 L=10u W=1u nf=1 ad=0.8p as=0.8p pd=3.6u ps=3.6u m=1
X2 IBIAS__t2 BIAS_OKB__t2 VSS__t3 VSS__t14 nfet_03v3 L=1u W=1u nf=1 ad=0.8p as=0.8p pd=3.6u ps=3.6u m=1
X3 N1__t2 CMPO__t1 VSS__t5 VSS__t15 nfet_03v3 L=0.5u W=1u nf=1 ad=0.8p as=0.8p pd=3.6u ps=3.6u m=1
X4 POR_RAW__t0 N1__t3 VSS__t7 VSS__t16 nfet_03v3 L=0.5u W=1u nf=1 ad=0.8p as=0.8p pd=3.6u ps=3.6u m=1
X5 BIAS_OKB__t4 BIAS_OK__t0 VSS__t6 VSS__t17 nfet_03v3 L=0.5u W=1u nf=1 ad=0.8p as=0.5p pd=3.6u ps=3u m=1
X6 NA__t2 SNS__t2 TN__t0 VSS__t18 nfet_03v3 L=1u W=2u nf=1 ad=1.6p as=1.6p pd=5.6u ps=5.6u m=1
X7 CMPO__t2 VREF__t0 TN__t2 VSS__t19 nfet_03v3 L=1u W=2u nf=1 ad=1.6p as=1.6p pd=5.6u ps=5.6u m=1
X8 IBIAS__t0 NBG__t1 VSS__t1 VSS__t21 nfet_03v3 L=2u W=2u nf=1 ad=1.6p as=1.6p pd=5.6u ps=5.6u m=1
X9 IBIAS__t1 BIAS_OK__t2 NBG__t2 VSS__t22 nfet_03v3 L=0.5u W=2u nf=1 ad=1.6p as=1.6p pd=5.6u ps=5.6u m=1
X10 NBG__t3 BIAS_OKB__t1 VSS__t8 VSS__t23 nfet_03v3 L=0.5u W=2u nf=1 ad=1.6p as=1.6p pd=5.6u ps=5.6u m=1
X11 CMPO__t3 BIAS_OKB__t3 VSS__t9 VSS__t20 nfet_03v3 L=1u W=2u nf=1 ad=1.6p as=1.6p pd=5.6u ps=5.6u m=1
X12 SNSB__t1 N1__t1 VSS__t4 VSS__t24 nfet_03v3 L=0.5u W=10u nf=1 ad=8p as=8p pd=21.6u ps=21.6u m=1
X13 N1__t0 CMPO__t0 VDD__t3 VDD__t4 pfet_03v3 L=0.5u W=2u nf=1 ad=1.6p as=1.6p pd=5.6u ps=5.6u m=1
X14 POR_RAW__t1 N1__t4 VDD__t9 VDD__t8 pfet_03v3 L=0.5u W=2u nf=1 ad=1.6p as=1.6p pd=5.6u ps=5.6u m=1
X15 NA__t0 NA__t1 VDDA__t0 VDD__t0 pfet_03v3 L=1u W=4u nf=1 ad=3.2p as=3.2p pd=9.6u ps=9.6u m=1
X16 CMPO__t4 NA__t3 VDDA__t2 VDD__t10 pfet_03v3 L=1u W=4u nf=1 ad=3.2p as=3.2p pd=9.6u ps=9.6u m=1
X17 VDDA__t1 BIAS_OKB__t0 VDD__t1 VDD__t2 pfet_03v3 L=0.5u W=4u nf=1 ad=3.2p as=3.2p pd=9.6u ps=9.6u m=1
X18 BIAS_OKB__t5 BIAS_OK__t1 VDD__t5 VDD__t6 pfet_03v3 L=0.5u W=2u nf=1 ad=1.6p as=1p pd=5.6u ps=5u m=1
X19 SNSB__t0 SNS__t1 VSS__t10 ppolyf_u_3k r_width=2u r_length=6769.23u
X20 VSS__t0 SNSB__t2 VSS__t11 ppolyf_u_3k r_width=2u r_length=775u
X21 SNS__t0 VDD__t7 VSS__t12 ppolyf_u_3k r_width=2u r_length=7897.44u

R_10_t0 SNS__t0 SNS 122.891188735
R_10_t1 SNS__t1 SNS 684.260298411
R_10_t2 SNS__t2 SNS 686.317212854
C_10 SNS VSS 5.2676745e-14
R_12_t0 NBG__t0 NBG 715.139441326
R_12_t1 NBG__t1 NBG 44.0457601943
R_12_t2 NBG__t2 NBG 257.887617601
R_12_t3 NBG__t3 NBG 499.88258088
C_12 NBG VSS 2.1326008e-14
R_14_t0 SNSB__t0 SNSB 212.505970377
R_14_t1 SNSB__t1 SNSB 688.024299088
R_14_t2 SNSB__t2 SNSB 513.046030534
C_14 SNSB VSS 4.4264354e-14
R_3_t0 VDDA__t0 VDDA 631.9122
R_3_t1 VDDA__t1 VDDA 616.937977251
R_3_t2 VDDA__t2 VDDA 14.9742227488
C_3 VDDA VSS 1.4679011e-14
R_4_t0 NA__t0 NA 288.034386996
R_4_t1 NA__t1 NA 288.034386996
R_4_t2 NA__t2 NA 692.332138375
R_4_t3 NA__t3 NA 116.445087634
C_4 NA VSS 1.5868526e-14
R_5_t0 CMPO__t0 CMPO 261.418858782
R_5_t1 CMPO__t1 CMPO 366.105615344
R_5_t2 CMPO__t2 CMPO 88.9071013133
R_5_t3 CMPO__t3 CMPO 324.899769804
R_5_t4 CMPO__t4 CMPO 340.793554757
C_5 CMPO VSS 1.7766709e-14
R_7_t0 N1__t0 N1 377.193158999
R_7_t1 N1__t1 N1 175.868361694
R_7_t2 N1__t2 N1 253.833596266
R_7_t3 N1__t3 N1 292.041043747
R_7_t4 N1__t4 N1 338.946339293
C_7 N1 VSS 1.7866109e-14
R_9_t0 TN__t0 TN 486.762381087
R_9_t1 TN__t1 TN 630.394143252
R_9_t2 TN__t2 TN 143.96957566
C_9 TN VSS 1.3588667e-14
RBIAS_OK_t0 BIAS_OK__t0 BIAS_OK 363.218515086
RBIAS_OK_t1 BIAS_OK__t1 BIAS_OK 369.383580086
RBIAS_OK_t2 BIAS_OK__t2 BIAS_OK 719.565404828
CBIAS_OK BIAS_OK VSS 1.5010689e-14
RBIAS_OKB_t0 BIAS_OKB__t0 BIAS_OKB 744.308889961
RBIAS_OKB_t1 BIAS_OKB__t1 BIAS_OKB 59.9080526262
RBIAS_OKB_t2 BIAS_OKB__t2 BIAS_OKB 17.0676522536
RBIAS_OKB_t3 BIAS_OKB__t3 BIAS_OKB 109.722398109
RBIAS_OKB_t4 BIAS_OKB__t4 BIAS_OKB 349.031750011
RBIAS_OKB_t5 BIAS_OKB__t5 BIAS_OKB 351.14495704
CBIAS_OKB BIAS_OKB VSS 2.1654538e-14
RIBIAS_t0 IBIAS__t0 IBIAS 533.695252733
RIBIAS_t1 IBIAS__t1 IBIAS 99.7987141232
RIBIAS_t2 IBIAS__t2 IBIAS 632.489533144
CIBIAS IBIAS VSS 1.5551286e-14
RPOR_RAW_t0 POR_RAW__t0 POR_RAW 630.2627
RPOR_RAW_t1 POR_RAW__t1 POR_RAW 630.2627
CPOR_RAW POR_RAW VSS 1.3389027e-14
RVDD_t0 VDD__t0 VDD 5.9041895961
RVDD_t1 VDD__t1 VDD 4.71508973949
RVDD_t2 VDD__t2 VDD 4.71508973949
RVDD_t3 VDD__t3 VDD 4.24096746289
RVDD_t4 VDD__t4 VDD 4.24096746289
RVDD_t5 VDD__t5 VDD 6.87650413981
RVDD_t6 VDD__t6 VDD 6.87650413981
RVDD_t7 VDD__t7 VDD 24.3165014744
RVDD_t8 VDD__t8 VDD 3.72828176386
RVDD_t9 VDD__t9 VDD 3.72828176386
RVDD_t10 VDD__t10 VDD 5.28662271739
CVDD VDD VSS 5.2337816e-14
RVREF_t0 VREF__t0 VREF 1314.9134
CVREF VREF VSS 1.1576327e-14
RVSS_t0 VSS__t0 VSS 21.9623916049
RVSS_t1 VSS__t1 VSS 3.68926797329
RVSS_t2 VSS__t2 VSS 4.28730713656
RVSS_t3 VSS__t3 VSS 2.98646338292
RVSS_t4 VSS__t4 VSS 2.71447557922
RVSS_t5 VSS__t5 VSS 2.3015019586
RVSS_t6 VSS__t6 VSS 1.57310764032
RVSS_t7 VSS__t7 VSS 2.09215843778
RVSS_t8 VSS__t8 VSS 3.21060999989
RVSS_t9 VSS__t9 VSS 2.52186312651
RVSS_t10 VSS__t10 VSS 15.4918826332
RVSS_t11 VSS__t11 VSS 21.9623916049
RVSS_t12 VSS__t12 VSS 6.28602125058
RVSS_t13 VSS__t13 VSS 4.28730713656
RVSS_t14 VSS__t14 VSS 2.98646338292
RVSS_t15 VSS__t15 VSS 2.3015019586
RVSS_t16 VSS__t16 VSS 2.09215843778
RVSS_t17 VSS__t17 VSS 1.57310764032
RVSS_t18 VSS__t18 VSS 5.09283406728
RVSS_t19 VSS__t19 VSS 4.84353174536
RVSS_t20 VSS__t20 VSS 2.52186312651
RVSS_t21 VSS__t21 VSS 3.68926797329
RVSS_t22 VSS__t22 VSS 3.42393662359
RVSS_t23 VSS__t23 VSS 3.21060999989
RVSS_t24 VSS__t24 VSS 2.71447557922
CVSS VSS VSS 1.99238424e-13
Ccc__10__14 SNS SNSB 1.8889e-17
Ccc__10_BIAS_OK SNS BIAS_OK 9.444e-18
Ccc__10_BIAS_OKB SNS BIAS_OKB 9.444e-18
Ccc__10_VDD SNS VDD 9.444e-18
Ccc__14_VDD SNSB VDD 9.444e-18
Rvsubs_dctie VSS 0 1e+12
.ends por_comparator
