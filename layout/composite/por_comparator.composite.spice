* por_comparator -- COMPOSITE post-layout netlist
* generated by layout/composite_netlist.py -- do not edit.
*
* WHAT THIS IS
*   MOS devices and interconnect parasitics taken from the LAYOUT
*     layout/reports/por_comparator/extracted-parasitics.spice
*     (klt extract --deck gf180mcu --parasitics), plus every non-MOS
*     device taken VERBATIM from the golden schematic export
*     design/netlist/por_comparator.spice.
*
* WHAT THIS IS NOT
*   It is NOT a parasitic-extracted analog core. The vertical PNPs,
*   poly resistors and MiM caps below are IDEAL SCHEMATIC DEVICES:
*   they are not drawn in the layout at all, so they carry no
*   extracted geometry, no parasitic R/C, and no layout-derived
*   matching. Any claim recorded against this netlist must say so in
*   the record's Claim field -- what it substantiates is real
*   interconnect parasitics loading the real MOS topology, and
*   nothing more. See layout/composite/AUDIT.md.
*
*   Device bodies are the other place this netlist takes connectivity
*   from the schematic: the curated deck draws no tap or well-label
*   layer, so an extracted body lands on a global substrate net or an
*   anonymous well net. Those are restored to the schematic's own
*   body nodes here, because a floating body cannot be simulated.
*
.subckt por_comparator VDD VSS IBIAS VREF BIAS_OK POR_RAW

* ---- MOS devices: extracted from the layout ----
* device instance $1 r0 *1 33.5,0.5 nfet
XM__1 TN NBG VSS VSS nfet_03v3 L=10u W=1u nf=1 ad=0.8p as=0.8p pd=3.6u ps=3.6u m=1
* device instance $2 r0 *1 52.4,0.5 nfet
XM__2 IBIAS BIAS_OKB VSS VSS nfet_03v3 L=1u W=1u nf=1 ad=0.8p as=0.8p pd=3.6u ps=3.6u m=1
* device instance $3 r0 *1 62.45,0.5 nfet
XM__3 N1 CMPO VSS VSS nfet_03v3 L=0.5u W=1u nf=1 ad=0.8p as=0.8p pd=3.6u ps=3.6u m=1
* device instance $4 r0 *1 65.55,0.5 nfet
XM__4 POR_RAW N1 VSS VSS nfet_03v3 L=0.5u W=1u nf=1 ad=0.8p as=0.8p pd=3.6u ps=3.6u m=1
* device instance $5 r0 *1 73.35,0.5 nfet
XM__5 BIAS_OKB BIAS_OK VSS VSS nfet_03v3 L=0.5u W=1u nf=1 ad=0.8p as=0.5p pd=3.6u ps=3u m=1
* device instance $6 r0 *1 21.8,1 nfet
XM__6 NA SNS TN VSS nfet_03v3 L=1u W=2u nf=1 ad=1.6p as=1.6p pd=5.6u ps=5.6u m=1
* device instance $7 r0 *1 25.4,1 nfet
XM__7 CMPO VREF TN VSS nfet_03v3 L=1u W=2u nf=1 ad=1.6p as=1.6p pd=5.6u ps=5.6u m=1
* device instance $8 r0 *1 42.1,1 nfet
XM__8 IBIAS NBG VSS VSS nfet_03v3 L=2u W=2u nf=1 ad=1.6p as=1.6p pd=5.6u ps=5.6u m=1
* device instance $9 r0 *1 45.95,1 nfet
XM__9 IBIAS BIAS_OK NBG VSS nfet_03v3 L=0.5u W=2u nf=1 ad=1.6p as=1.6p pd=5.6u ps=5.6u m=1
* device instance $10 r0 *1 49.05,1 nfet
XM__10 NBG BIAS_OKB VSS VSS nfet_03v3 L=0.5u W=2u nf=1 ad=1.6p as=1.6p pd=5.6u ps=5.6u m=1
* device instance $11 r0 *1 59.1,1 nfet
XM__11 CMPO BIAS_OKB VSS VSS nfet_03v3 L=1u W=2u nf=1 ad=1.6p as=1.6p pd=5.6u ps=5.6u m=1
* device instance $12 r0 *1 55.75,5 nfet
XM__12 SNSB N1 VSS VSS nfet_03v3 L=0.5u W=10u nf=1 ad=8p as=8p pd=21.6u ps=21.6u m=1
* device instance $13 r0 *1 11.35,1 pfet
XM__13 N1 CMPO VDD VDD pfet_03v3 L=0.5u W=2u nf=1 ad=1.6p as=1.6p pd=5.6u ps=5.6u m=1
* device instance $14 r0 *1 14.45,1 pfet
XM__14 POR_RAW N1 VDD VDD pfet_03v3 L=0.5u W=2u nf=1 ad=1.6p as=1.6p pd=5.6u ps=5.6u m=1
* device instance $15 r0 *1 1.3,2 pfet
XM__15 NA NA VDDA VDD pfet_03v3 L=1u W=4u nf=1 ad=3.2p as=3.2p pd=9.6u ps=9.6u m=1
* device instance $16 r0 *1 4.9,2 pfet
XM__16 CMPO NA VDDA VDD pfet_03v3 L=1u W=4u nf=1 ad=3.2p as=3.2p pd=9.6u ps=9.6u m=1
* device instance $17 r0 *1 8.25,2 pfet
XM__17 VDDA BIAS_OKB VDD VDD pfet_03v3 L=0.5u W=4u nf=1 ad=3.2p as=3.2p pd=9.6u ps=9.6u m=1
* device instance $18 r0 *1 73.35,4 pfet
XM__18 BIAS_OKB BIAS_OK VDD VDD pfet_03v3 L=0.5u W=2u nf=1 ad=1.6p as=1p pd=5.6u ps=5u m=1

* ---- interconnect parasitics: extracted from the layout ----
* One series R + one lumped C to substrate per net, from the deck's
* curated sheet-resistance / capacitance table (klt extract
* --parasitics). First order, not a field solve.
Rpar__10 SNS SNS__par 1614.04
Cpar__10 SNS__par VSS 1.38696e-14
Rpar__12 NBG NBG__par 1516.96
Cpar__12 NBG__par VSS 2.1326e-14
Rpar__14 SNSB SNSB__par 1556.35
Cpar__14 SNSB__par VSS 1.43923e-14
Rpar__3 VDDA VDDA__par 1263.82
Cpar__3 VDDA__par VSS 1.4679e-14
Rpar__4 NA NA__par 1384.85
Cpar__4 NA__par VSS 1.58685e-14
Rpar__5 CMPO CMPO__par 1382.12
Cpar__5 CMPO__par VSS 1.77667e-14
Rpar__7 N1 N1__par 1437.88
Cpar__7 N1__par VSS 1.78661e-14
Rpar__9 TN TN__par 1261.13
Cpar__9 TN__par VSS 1.35887e-14
Rpar_BIAS_OK BIAS_OK BIAS_OK__par 1452.17
Cpar_BIAS_OK BIAS_OK__par VSS 1.50155e-14
Rpar_BIAS_OKB BIAS_OKB BIAS_OKB__par 1631.18
Cpar_BIAS_OKB BIAS_OKB__par VSS 2.16593e-14
Rpar_IBIAS IBIAS IBIAS__par 1265.98
Cpar_IBIAS IBIAS__par VSS 1.55513e-14
Rpar_POR_RAW POR_RAW POR_RAW__par 1260.53
Cpar_POR_RAW POR_RAW__par VSS 1.3389e-14
Rpar_VDD VDD VDD__par 26.6687
Cpar_VDD VDD__par VSS 2.23031e-14
Rpar_VREF VREF VREF__par 1314.91
Cpar_VREF VREF__par VSS 1.15763e-14
Rpar_VSS VSS VSS__par 77.3616
Cpar_VSS VSS__par VSS 1.47874e-13

* ---- non-MOS devices: IDEAL, verbatim from the schematic ----
* from por_comparator
XRTOP SNS VDD VSS ppolyf_u_3k r_width=2u r_length=7897.44u m=1
* from por_comparator
XRBOT SNSB SNS VSS ppolyf_u_3k r_width=2u r_length=6769.23u m=1
* from por_comparator
XRHYS VSS SNSB VSS ppolyf_u_3k r_width=2u r_length=775.0u m=1

.ends por_comparator
