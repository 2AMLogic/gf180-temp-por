* por-output-chain-deglitch -- stimulus half of the testbench fragment.
*
* The other half is a verbatim copy of design/netlist/por_output_chain.spice,
* appended by sim/build_tb.py to produce tb_por_deglitch.spice. Edit THIS file
* (or the schematic), never the generated fragment.
*
* Netlist FRAGMENT: no .include / .lib / .temp / .control / .end -- the
* harness owns those. Parameters it supplies: vdd_val, vdd_nom, temp_c.
*
* WHAT THIS EXPERIMENT SUBSTANTIATES
*
* spec/target-spec.md#por-brownout owns a TBD this issue has to fill: the
* deglitch dwell time, which must be <= T_dip,min = 10 us for the brownout row
* to hold at all. Per DR-005 the dwell is this cell's job and is a separate,
* time-domain mechanism from the comparator's static hysteresis (#10) -- the
* two are not interchangeable and must not be double-counted.
*
* Three things are measured, all on the same run:
*
*   1. DWELL. POR_RAW falls; how long until RESETn is asserted again? That is
*      the deglitch dwell plus a few ns of logic, and it is what T_dip,min has
*      to exceed. Measured end-to-end at the pin on xdut1, and also at the
*      internal PGDG node so the dwell can be attributed to the filter rather
*      than to the rest of the chain.
*   2. QUALIFYING-DIP CAPTURE. The dip used for (1) is exactly 10 us -- the
*      spec's own T_dip,min -- not a comfortable long one. A dwell that is
*      nominally under 10 us but creeps over it at a corner shows up here as a
*      RESETn that never reaches a valid low, which the vmin check catches.
*   3. NO EARLY / DOUBLE PULSE. Sub-dwell chatter on POR_RAW is applied twice:
*      once while RESETn is asserted (must not restart or truncate the pulse,
*      and must not produce an early release) and once after it has released
*      (must not produce a spurious re-assertion). This is the "POR_RAW
*      chatters near threshold before the deglitch settles" edge case.
*   4. REJECTION-WIDTH MARGIN (#200). A THIRD chatter burst, 1.05 us wide --
*      5 % wider than the 1 us the checks above use -- is applied after the
*      qualifying dip has restarted the pulse. Its job is to put a number on
*      how much width margin the filter has left, at every one of the 81 PVT
*      points, instead of only asserting that one width is rejected. What it
*      measures is the one-shot's own charge (TIM before vs. its minimum over
*      the burst), because losing timer charge -- XMDIS conducting and the
*      reset pulse restarting -- is the functional failure; PGDG merely
*      drooping is not.
*
*      WHY 1.05 us. control/width_results.md walks the glitch width at the two
*      fastest corners and brackets the post-layout netlist's rejection ceiling
*      between 1.0 us (rejected) and 1.25 us (disturbed) -- the schematic's
*      bracket is 1.75 / 2.0 us. 1.05 us is inside that bracket: wider than the
*      burst the checks above use, and still a width the design AS DRAWN
*      rejects at every one of the 81 points, which is what makes it a check
*      rather than a known failure. The control answers this at two corners
*      and is overwritten on every run; this burst carries the same question
*      onto the corner grid, where the answer is recorded append-only.
*
*      It sits AFTER every other measurement window on purpose: nothing in
*      this stimulus changes before 12.99 ms, so every measurement that
*      existed before it did is bit-identical to a run without it (verified
*      across all 81 points, both netlists) and the records stay comparable.
*
* TWO DUTS, BECAUSE THE DWELL SCALES AS 1/IBIAS
*
*   xdut1  IBIAS = 0.5 uA    DR-005 nominal. Carries the end-to-end RESETn
*                            measurements, which need a prior release and
*                            therefore a timer that finishes in time.
*   xdut2  IBIAS = 0.25 uA   half nominal -- the stress case for the <= 10 us
*                            dwell, since less bias current means a slower
*                            filter. Its timer takes ~2x as long, so only its
*                            internal PGDG dwell is asserted on; that is the
*                            filter output and is the number the spec row
*                            actually constrains.
*
* TIMELINE
*
*   0     -> 100 us   VDD ramps 0 -> vdd_val. POR_RAW low.
*   300 us            POR_RAW high: release conditions met, both timers start.
*   1.0 / 1.1 / 1.2 ms  three 1 us LOW glitches on POR_RAW, DURING assertion.
*   (<=10 ms)         xdut1 releases -- once.
*   11.0 / 11.1 / 11.2 ms  three 1 us LOW glitches, AFTER release.
*   12.0 ms           POR_RAW low for exactly 10 us: the qualifying brownout
*                     dip of the por-brownout row. RESETn must re-assert and
*                     the full pulse must regenerate.
*   13.0 / 13.1 / 13.2 ms  three 1.05 us LOW glitches, DURING the regenerated
*                     pulse -- placed at the same 1.0/1.1/1.2 ms offset from
*                     the restart at 12.01 ms that the first battery has from
*                     the start at 300.1 us, so the one-shot is charging
*                     steadily in both, the same regime. The regenerated pulse
*                     is >4 ms at every corner recorded so far, so RESETn is
*                     still asserted throughout this burst.
*   13.6 ms           end.

vsup vdd 0 PWL(0 0 100u {vdd_val} 14m {vdd_val})

* POR_RAW: high from 300 us, with three batteries of sub-dwell chatter (two at
* 1 us, one at 1.05 us) and one 10 us qualifying dip. Edges are 100 ns so the
* glitches are genuinely as wide at the pin as they are drawn here rather than
* being softened into nothing by the source.
vpr por_raw 0 PWL(0 0
+ 300u 0 300.1u {vdd_val}
+ 999.9u {vdd_val} 1000u 0 1001u 0 1001.1u {vdd_val}
+ 1099.9u {vdd_val} 1100u 0 1101u 0 1101.1u {vdd_val}
+ 1199.9u {vdd_val} 1200u 0 1201u 0 1201.1u {vdd_val}
+ 10999.9u {vdd_val} 11000u 0 11001u 0 11001.1u {vdd_val}
+ 11099.9u {vdd_val} 11100u 0 11101u 0 11101.1u {vdd_val}
+ 11199.9u {vdd_val} 11200u 0 11201u 0 11201.1u {vdd_val}
+ 11999.9u {vdd_val} 12000u 0 12010u 0 12010.1u {vdd_val}
+ 12999.9u {vdd_val} 13000u 0 13001.05u 0 13001.15u {vdd_val}
+ 13099.9u {vdd_val} 13100u 0 13101.05u 0 13101.15u {vdd_val}
+ 13199.9u {vdd_val} 13200u 0 13201.05u 0 13201.15u {vdd_val}
+ 14m {vdd_val})

Bib1 vdd nib1 i='500n*min(1, max(0, (v(vdd)-1.5)/0.5))'
vib1 nib1 ibias1 dc 0
Bib2 vdd nib2 i='250n*min(1, max(0, (v(vdd)-1.5)/0.5))'
vib2 nib2 ibias2 dc 0

vd1 vdd vdd1 dc 0
vd2 vdd vdd2 dc 0

Cl1 resetn1 0 5p
Rl1 resetn1 0 1T
Cl2 resetn2 0 5p
Rl2 resetn2 0 1T

xdut1 vdd1 0 ibias1 por_raw resetn1 por_output_chain
xdut2 vdd2 0 ibias2 por_raw resetn2 por_output_chain
