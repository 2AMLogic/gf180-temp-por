* Frozen netlist snapshot for record 20260811-055424-d0ee17d
* source     : sim/por-output-chain-floor/testbench-postlayout/tb_por_floor_postlayout.spice
* sha256     : db95e6f47b01169ab82bb7778a24f82aaf9923c6721f6401c8d86aa6d6d44084
* This is a verbatim copy taken at record time. Do not edit.
* tb_por_floor_postlayout -- GENERATED by sim/build_tb.py
* Do not edit. Sources:
*   sim/por-output-chain-floor/testbench/stimulus.spice
*   layout/postlayout/por_output_chain.spice  (sha256 2722ab83a3bd292d5e206d3cad6543db15a79d66e338d8efeea338094a2c25cb)
* Regenerate with:
*   python3 sim/build_tb.py

* por-output-chain-floor -- stimulus half of the testbench fragment.
*
* The other half is a verbatim copy of design/netlist/por_output_chain.spice,
* appended by sim/build_tb.py to produce tb_por_floor.spice. Edit THIS file
* (or the schematic), never the generated fragment.
*
* Netlist FRAGMENT: no .include / .lib / .temp / .control / .end -- the
* harness owns those. Parameters it supplies: vdd_val, vdd_nom, temp_c.
*
* WHAT THIS EXPERIMENT SUBSTANTIATES
*
* spec/target-spec.md#por-reset-valid-floor: V(RESETn) <= min(0.1*VDD, 0.3 V)
* into the reset-pulse load, for ALL VDD >= 0 V. This is the numeric row DR-004
* requires #12 to fill, and it is a genuinely hard requirement rather than a
* formality: as VDD -> 0 the on/off ratio of a MOSFET collapses towards 1
* (Ion/Ioff ~ exp(VDD/nVt), which is only 1.3x at VDD = 10 mV), so a biasing
* argument cannot deliver the 10x the row asks for. Only device GEOMETRY can,
* which is why XMON/XMOP are 20:1 in W/L and the release NAND is deliberately
* PMOS-heavy / NMOS-light.
*
* WHY A SLOW RAMP AND NOT A DC SWEEP
*
* A tran ramp is parameterisable against the harness's per-point vdd_val in a
* way a `dc` command inside the harness's control block is not, and it is the
* stronger evidence anyway: it exercises the same handoff DR-004 describes --
* assist-held below the comparator floor, comparator-driven above it -- rather
* than a sequence of unrelated DC solutions. The ramp is deliberately slow
* (~0.66 kV/s, three decades inside the ratified por-ramp-rate envelope) so
* every point is quasi-static; the first millisecond covers 0 -> 50 mV at
* ~0.1 mV resolution, which is where the leakage-divider argument is weakest
* and where a coarse sweep would simply miss the failure.
*
* TWO DUTS, BECAUSE THE REQUIREMENT IS "NOT GATED BY POR_RAW"
*
*   xdut1  POR_RAW held low         the specified case: the comparator is below
*                                   its floor and its output is not driving.
*   xdut2  POR_RAW driven to VDD    the pathological case DR-004 actually warns
*                                   about -- POR_RAW is "undefined" below the
*                                   comparator floor, so a below-floor assist
*                                   that quietly assumes it reads low is not an
*                                   assist. Checked only for VDD < 1.5 V: above
*                                   that the comparator has a floor and a real
*                                   decision, and DUT2's timer legitimately runs.

vsup vdd 0 PWL(0 0 1m 0.05 6m {vdd_val} 7m {vdd_val})

* IBIAS: bias_core's 0.5 uA reference, coming up with the rail (same model as
* sim/temp-core-startup/). Below ~1.5 V there is no bias core, which is exactly
* the regime this experiment is about.
Bib1 vdd nib1 i='500n*min(1, max(0, (v(vdd)-1.5)/0.5))'
vib1 nib1 ibias1 dc 0
Bib2 vdd nib2 i='500n*min(1, max(0, (v(vdd)-1.5)/0.5))'
vib2 nib2 ibias2 dc 0

vd1 vdd vdd1 dc 0
vd2 vdd vdd2 dc 0

vpr1 por_raw1 0 dc 0
Epr2 por_raw2 0 vdd 0 1

* por-reset-pulse measurement load: 5 pF, no DC load. The 1 Tohm is a solver
* aid, not a load -- at 3.63 V it is 3.6 pA, four orders below anything here.
Cl1 resetn1 0 5p
Rl1 resetn1 0 1T
Cl2 resetn2 0 5p
Rl2 resetn2 0 1T

xdut1 vdd1 0 ibias1 por_raw1 resetn1 por_output_chain
xdut2 vdd2 0 ibias2 por_raw2 resetn2 por_output_chain

* por_output_chain -- post-layout netlist
* GENERATED by layout/postlayout.py -- do not edit.
*
* FROM THE LAYOUT: every device and its dimensions, the whole
*   topology, and first-order interconnect R/C on 18/30 nets
*   (sigma 828.6 fF). klt 0.2.0, deck gf180mcu,
*   GDS sha256 475c7feaa83591e1...
* Net names are the schematic's, restored through klt lvs's own net
*   correspondence -- match, 30/30 nets, every one paired.
*
* NOT FROM THE LAYOUT -- see layout/postlayout/AUDIT.md:
*   12 body/plate net(s) tied to the net the schematic puts
*   them on. The extraction deck's connectivity stack does not reach
*   an Nwell, a substrate ring, a bipolar base well or a MiM plate,
*   so they extract isolated and would otherwise float.
*   No ideal device: every golden device is drawn.
*
.subckt por_output_chain VDD VSS IBIAS POR_RAW RESETn

* --- drawn devices ---
X1 PDN IBIAS VSS VSS nfet_03v3 L=25u W=0.5u nf=1 ad=0.4p as=0.4p pd=2.6u ps=2.6u m=1
X2 PGDGB PGDG VSS VSS nfet_03v3 L=2u W=0.5u nf=1 ad=0.4p as=0.4p pd=2.6u ps=2.6u m=1
X3 ND1 NDL VSS VSS nfet_03v3 L=10u W=0.5u nf=1 ad=0.4p as=0.4p pd=2.6u ps=2.6u m=1
X4 NDG POR_RAW NDGN VSS nfet_03v3 L=0.5u W=1u nf=1 ad=0.8p as=0.8p pd=3.6u ps=3.6u m=1
X5 TIM PGDGB VSS VSS nfet_03v3 L=1u W=1u nf=1 ad=0.8p as=0.8p pd=3.6u ps=3.6u m=1
X6 TRIP ND1 VSS VSS nfet_03v3 L=1u W=1u nf=1 ad=0.8p as=0.8p pd=3.6u ps=3.6u m=1
X7 ND1 RESETn VSS VSS nfet_03v3 L=1u W=1u nf=1 ad=0.8p as=0.8p pd=3.6u ps=3.6u m=1
X8 NDL NDL VSS VSS nfet_03v3 L=10u W=2u nf=1 ad=1.6p as=1.6p pd=5.6u ps=5.6u m=1
X9 PGDG NDG VSS VSS nfet_03v3 L=0.5u W=2u nf=1 ad=1.6p as=1.6p pd=5.6u ps=5.6u m=1
X10 RSTB TRIP NNAND VSS nfet_03v3 L=0.5u W=2u nf=1 ad=1.6p as=1.6p pd=5.6u ps=5.6u m=1
X11 NNAND PGDG VSS VSS nfet_03v3 L=0.5u W=2u nf=1 ad=1.6p as=1.6p pd=5.6u ps=5.6u m=1
X12 IBIAS IBIAS VSS VSS nfet_03v3 L=4u W=4u nf=1 ad=3.2p as=3.2p pd=9.6u ps=9.6u m=1
X13 NDGN NDL VSS VSS nfet_03v3 L=10u W=10u nf=1 ad=8p as=8p pd=21.6u ps=21.6u m=1
X14 RESETn RSTB VSS VSS nfet_03v3 L=0.5u W=10u nf=1 ad=8p as=8p pd=21.6u ps=21.6u m=1
X15 NTS PDN VDD VDD pfet_03v3 L=10u W=0.5u nf=1 ad=0.4p as=0.4p pd=2.6u ps=2.6u m=1
X16 TRIP PDN VDD VDD pfet_03v3 L=10u W=0.5u nf=1 ad=0.4p as=0.4p pd=2.6u ps=2.6u m=1
X17 PGDG NDG VDD VDD pfet_03v3 L=2u W=0.5u nf=1 ad=0.4p as=0.4p pd=2.6u ps=2.6u m=1
X18 RSTB RESETn VDD VDD pfet_03v3 L=10u W=0.5u nf=1 ad=0.4p as=0.4p pd=2.6u ps=2.6u m=1
X19 NDG POR_RAW NDGP VDD pfet_03v3 L=0.5u W=1u nf=1 ad=0.8p as=0.8p pd=3.6u ps=3.6u m=1
X20 RESETn RSTB VDD VDD pfet_03v3 L=1u W=1u nf=1 ad=0.8p as=0.8p pd=3.6u ps=3.6u m=1
X21 PDN PDN VDD VDD pfet_03v3 L=10u W=2u nf=1 ad=1.6p as=1.6p pd=5.6u ps=5.6u m=1
X22 NDL PDN VDD VDD pfet_03v3 L=10u W=2u nf=1 ad=1.6p as=1.6p pd=5.6u ps=5.6u m=1
X23 PGDGB PGDG VDD VDD pfet_03v3 L=0.5u W=2u nf=1 ad=1.6p as=1.6p pd=5.6u ps=5.6u m=1
X24 TIM PGDGB NTS VDD pfet_03v3 L=1u W=2u nf=1 ad=1.6p as=1.6p pd=5.6u ps=5.6u m=1
X25 ND1 TIM VDD VDD pfet_03v3 L=1u W=2u nf=1 ad=1.6p as=1.6p pd=5.6u ps=5.6u m=1
X26 RSTB TRIP VDD VDD pfet_03v3 L=0.5u W=4u nf=1 ad=3.2p as=3.2p pd=9.6u ps=9.6u m=1
X27 RSTB PGDG VDD VDD pfet_03v3 L=0.5u W=4u nf=1 ad=3.2p as=3.2p pd=9.6u ps=9.6u m=1
X28 NDGP PDN VDD VDD pfet_03v3 L=10u W=10u nf=1 ad=8p as=8p pd=21.6u ps=21.6u m=1
X29 NDG VSS cap_mim_2f0_m3m4_noshield c_width=11u c_length=11u
X30 TIM VSS cap_mim_2f0_m3m4_noshield c_width=28u c_length=28u
X31 TIM VSS cap_mim_2f0_m3m4_noshield c_width=28u c_length=28u
X32 TIM VSS cap_mim_2f0_m3m4_noshield c_width=28u c_length=28u
X33 TIM VSS cap_mim_2f0_m3m4_noshield c_width=28u c_length=28u

R_10 NDGN NDGN__par 3937.0807
C_10 NDGN__par VSS 3.4262384e-14
R_11 NDG NDG__par 4070.1194
C_11 NDG__par VSS 3.8582127e-14
R_12 PGDG PGDG__par 4189.4122
C_12 PGDG__par VSS 4.2342204e-14
R_13 TIM TIM__par 4003.4777
C_13 TIM__par VSS 3.7210339e-14
R_14 TRIP TRIP__par 4060.1793
C_14 TRIP__par VSS 3.9476253e-14
R_15 NNAND NNAND__par 3939.9598
C_15 NNAND__par VSS 3.5425418e-14
R_16 NDGP NDGP__par 3936.7209
C_16 NDGP__par VSS 3.4117005e-14
R_17 RSTB RSTB__par 4076.1659
C_17 RSTB__par VSS 4.4250826e-14
R_2 PDN PDN__par 4872.473
C_2 PDN__par VSS 5.6524204e-14
R_3 NDL NDL__par 4462.4943
C_3 NDL__par VSS 4.7374149e-14
R_5 PGDGB PGDGB__par 4066.8624
C_5 PGDGB__par VSS 3.8940744e-14
R_6 ND1 ND1__par 4009.3404
C_6 ND1__par VSS 3.953615e-14
R_8 NTS NTS__par 3938.5202
C_8 NTS__par VSS 3.4843901e-14
RIBIAS IBIAS IBIAS__par 4398.6611
CIBIAS IBIAS__par VSS 4.5280553e-14
RPOR_RAW POR_RAW POR_RAW__par 4047.2842
CPOR_RAW POR_RAW__par VSS 3.435215e-14
RRESETn RESETn RESETn__par 4167.0798
CRESETn RESETn__par VSS 4.4306787e-14
RVDD VDD VDD__par 79.7582
CVDD VDD__par VSS 6.9000979e-14
RVSS VSS VSS__par 66.7327
CVSS VSS__par VSS 1.12754344e-13
.ends por_output_chain
