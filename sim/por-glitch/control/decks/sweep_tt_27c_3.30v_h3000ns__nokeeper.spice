* por-glitch depth/duration sweep @ tt / 27 C / 3.3 V / floor 0.2 V / hold 3000 ns / arm=nokeeper -- GENERATED by run_depth_sweep.py, do not edit
* pdk=gf180mcuD@c6d73a35f524070e85faff4a6a9eef49553ebc2b

.param vdd_val=3.3
.param glitch_v=0.2
.param t_fall=0.0200001
.param t_hold=0.0200031
.param t_rise=0.0200032
.param stop_s=0.03

.include "/Users/rwalters/.volare/gf180mcuD/libs.tech/ngspice/design.ngspice"
.lib "/Users/rwalters/.volare/gf180mcuD/libs.tech/ngspice/sm141064.ngspice" typical
.lib "/Users/rwalters/.volare/gf180mcuD/libs.tech/ngspice/sm141064.ngspice" res_typical
.lib "/Users/rwalters/.volare/gf180mcuD/libs.tech/ngspice/sm141064.ngspice" bjt_typical
.lib "/Users/rwalters/.volare/gf180mcuD/libs.tech/ngspice/sm141064.ngspice" diode_typical
.lib "/Users/rwalters/.volare/gf180mcuD/libs.tech/ngspice/sm141064.ngspice" moscap_typical
.lib "/Users/rwalters/.volare/gf180mcuD/libs.tech/ngspice/sm141064.ngspice" mimcap_typical

.temp 27.0
.options reltol=1e-5
.options abstol=1e-15
.options vntol=1e-9

.include "../depth_sweep.spice"
.include "sweep_dut_nokeeper.spice"

.tran 20u {stop_s}

.control
set numdgt=10
set noaskquit
run
wrdata tt_27c_3.30v_h3000ns__nokeeper.csv v(vdd) v(xdut.por_raw) v(xdut.xpor.pgdg) v(xdut.vref) v(resetn) v(xdut.xpor.tim)
.endc
.end
