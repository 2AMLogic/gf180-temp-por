* por_output_chain -- COMPOSITE post-layout netlist
* generated by layout/composite_netlist.py -- do not edit.
*
* WHAT THIS IS
*   MOS devices and interconnect parasitics taken from the LAYOUT
*     layout/reports/por_output_chain/extracted-parasitics.spice
*     (klt extract --deck gf180mcu --parasitics), plus every non-MOS
*     device taken VERBATIM from the golden schematic export
*     design/netlist/por_output_chain.spice.
*
* WHAT THIS IS NOT
*   It is NOT a parasitic-extracted analog core. The vertical PNPs,
*   poly resistors and MiM caps below are IDEAL SCHEMATIC DEVICES:
*   they are not drawn in the layout at all, so they carry no
*   extracted geometry, no parasitic R/C, and no layout-derived
*   matching. Any claim recorded against this netlist must say so in
*   the record's Claim field -- what it substantiates is real
*   interconnect parasitics loading the real MOS topology, and
*   nothing more. See layout/composite/AUDIT.md.
*
*   Device bodies are the other place this netlist takes connectivity
*   from the schematic: the curated deck draws no tap or well-label
*   layer, so an extracted body lands on a global substrate net or an
*   anonymous well net. Those are restored to the schematic's own
*   body nodes here, because a floating body cannot be simulated.
*
.subckt por_output_chain VDD VSS IBIAS POR_RAW RESETn

* ---- MOS devices: extracted from the layout ----
* device instance $1 r0 *1 19.9,0.25 nfet
XM__1 PDN IBIAS VSS VSS nfet_03v3 L=25u W=0.5u nf=1 ad=0.4p as=0.4p pd=2.6u ps=2.6u m=1
* device instance $2 r0 *1 67.4,0.25 nfet
XM__2 PGDGB PGDG VSS VSS nfet_03v3 L=2u W=0.5u nf=1 ad=0.4p as=0.4p pd=2.6u ps=2.6u m=1
* device instance $3 r0 *1 79.6,0.25 nfet
XM__3 ND1 NDL VSS VSS nfet_03v3 L=10u W=0.5u nf=1 ad=0.4p as=0.4p pd=2.6u ps=2.6u m=1
* device instance $4 r0 *1 60.45,0.5 nfet
XM__4 NDG POR_RAW NDGN VSS nfet_03v3 L=0.5u W=1u nf=1 ad=0.8p as=0.8p pd=3.6u ps=3.6u m=1
* device instance $5 r0 *1 71.5,0.5 nfet
XM__5 TIM PGDGB VSS VSS nfet_03v3 L=1u W=1u nf=1 ad=0.8p as=0.8p pd=3.6u ps=3.6u m=1
* device instance $6 r0 *1 87.7,0.5 nfet
XM__6 TRIP ND1 VSS VSS nfet_03v3 L=1u W=1u nf=1 ad=0.8p as=0.8p pd=3.6u ps=3.6u m=1
* device instance $7 r0 *1 40,1 nfet
XM__7 NDL NDL VSS VSS nfet_03v3 L=10u W=2u nf=1 ad=1.6p as=1.6p pd=5.6u ps=5.6u m=1
* device instance $8 r0 *1 63.55,1 nfet
XM__8 PGDG NDG VSS VSS nfet_03v3 L=0.5u W=2u nf=1 ad=1.6p as=1.6p pd=5.6u ps=5.6u m=1
* device instance $9 r0 *1 91.05,1 nfet
XM__9 RSTB TRIP NNAND VSS nfet_03v3 L=0.5u W=2u nf=1 ad=1.6p as=1.6p pd=5.6u ps=5.6u m=1
* device instance $10 r0 *1 94.15,1 nfet
XM__10 NNAND PGDG VSS VSS nfet_03v3 L=0.5u W=2u nf=1 ad=1.6p as=1.6p pd=5.6u ps=5.6u m=1
* device instance $11 r0 *1 2.8,2 nfet
XM__11 IBIAS IBIAS VSS VSS nfet_03v3 L=4u W=4u nf=1 ad=3.2p as=3.2p pd=9.6u ps=9.6u m=1
* device instance $12 r0 *1 52.6,5 nfet
XM__12 NDGN NDL VSS VSS nfet_03v3 L=10u W=10u nf=1 ad=8p as=8p pd=21.6u ps=21.6u m=1
* device instance $13 r0 *1 208.65,5 nfet
XM__13 RESETn RSTB VSS VSS nfet_03v3 L=0.5u W=10u nf=1 ad=8p as=8p pd=21.6u ps=21.6u m=1
* device instance $14 r0 *1 143.8,0.25 pfet
XM__14 NTS PDN VDD VDD pfet_03v3 L=10u W=0.5u nf=1 ad=0.4p as=0.4p pd=2.6u ps=2.6u m=1
* device instance $15 r0 *1 156.4,0.25 pfet
XM__15 TRIP PDN VDD VDD pfet_03v3 L=10u W=0.5u nf=1 ad=0.4p as=0.4p pd=2.6u ps=2.6u m=1
* device instance $16 r0 *1 168.1,0.25 pfet
XM__16 PGDG NDG VDD VDD pfet_03v3 L=2u W=0.5u nf=1 ad=0.4p as=0.4p pd=2.6u ps=2.6u m=1
* device instance $17 r0 *1 193.2,0.25 pfet
XM__17 RSTB RESETn VDD VDD pfet_03v3 L=10u W=0.5u nf=1 ad=0.4p as=0.4p pd=2.6u ps=2.6u m=1
* device instance $18 r0 *1 164.25,0.5 pfet
XM__18 NDG POR_RAW NDGP VDD pfet_03v3 L=0.5u W=1u nf=1 ad=0.8p as=0.8p pd=3.6u ps=3.6u m=1
* device instance $19 r0 *1 201.3,0.5 pfet
XM__19 RESETn RSTB VDD VDD pfet_03v3 L=1u W=1u nf=1 ad=0.8p as=0.8p pd=3.6u ps=3.6u m=1
* device instance $20 r0 *1 106,1 pfet
XM__20 PDN PDN VDD VDD pfet_03v3 L=10u W=2u nf=1 ad=1.6p as=1.6p pd=5.6u ps=5.6u m=1
* device instance $21 r0 *1 118.6,1 pfet
XM__21 NDL PDN VDD VDD pfet_03v3 L=10u W=2u nf=1 ad=1.6p as=1.6p pd=5.6u ps=5.6u m=1
* device instance $22 r0 *1 171.95,1 pfet
XM__22 PGDGB PGDG VDD VDD pfet_03v3 L=0.5u W=2u nf=1 ad=1.6p as=1.6p pd=5.6u ps=5.6u m=1
* device instance $23 r0 *1 175.3,1 pfet
XM__23 TIM PGDGB NTS VDD pfet_03v3 L=1u W=2u nf=1 ad=1.6p as=1.6p pd=5.6u ps=5.6u m=1
* device instance $24 r0 *1 178.9,1 pfet
XM__24 ND1 TIM VDD VDD pfet_03v3 L=1u W=2u nf=1 ad=1.6p as=1.6p pd=5.6u ps=5.6u m=1
* device instance $25 r0 *1 182.25,2 pfet
XM__25 RSTB TRIP VDD VDD pfet_03v3 L=0.5u W=4u nf=1 ad=3.2p as=3.2p pd=9.6u ps=9.6u m=1
* device instance $26 r0 *1 185.35,2 pfet
XM__26 RSTB PGDG VDD VDD pfet_03v3 L=0.5u W=4u nf=1 ad=3.2p as=3.2p pd=9.6u ps=9.6u m=1
* device instance $27 r0 *1 131.2,5 pfet
XM__27 NDGP PDN VDD VDD pfet_03v3 L=10u W=10u nf=1 ad=8p as=8p pd=21.6u ps=21.6u m=1

* ---- interconnect parasitics: extracted from the layout ----
* One series R + one lumped C to substrate per net, from the deck's
* curated sheet-resistance / capacitance table (klt extract
* --parasitics). First order, not a field solve.
Rpar__10 NDGN NDGN__par 3871.38
Cpar__10 NDGN__par VSS 3.3743e-14
Rpar__11 NDG NDG__par 4004.42
Cpar__11 NDG__par VSS 3.80628e-14
Rpar__12 PGDG PGDG__par 4123.71
Cpar__12 PGDG__par VSS 4.18228e-14
Rpar__13 TIM TIM__par 3937.78
Cpar__13 TIM__par VSS 3.6691e-14
Rpar__14 TRIP TRIP__par 3994.48
Cpar__14 TRIP__par VSS 3.89569e-14
Rpar__15 NNAND NNAND__par 3874.26
Cpar__15 NNAND__par VSS 3.49061e-14
Rpar__16 NDGP NDGP__par 3871.02
Cpar__16 NDGP__par VSS 3.35976e-14
Rpar__17 RSTB RSTB__par 4010.47
Cpar__17 RSTB__par VSS 4.37315e-14
Rpar__2 PDN PDN__par 4808.76
Cpar__2 PDN__par VSS 5.60048e-14
Rpar__3 NDL NDL__par 4397.85
Cpar__3 NDL__par VSS 4.68548e-14
Rpar__5 PGDGB PGDGB__par 4001.16
Cpar__5 PGDGB__par VSS 3.84214e-14
Rpar__6 ND1 ND1__par 3938.54
Cpar__6 ND1__par VSS 3.69999e-14
Rpar__8 NTS NTS__par 3872.82
Cpar__8 NTS__par VSS 3.43245e-14
Rpar_IBIAS IBIAS IBIAS__par 4334.04
Cpar_IBIAS IBIAS__par VSS 4.47612e-14
Rpar_POR_RAW POR_RAW POR_RAW__par 3981.59
Cpar_POR_RAW POR_RAW__par VSS 3.38328e-14
Rpar_RESETn RESETn RESETn__par 4035.82
Cpar_RESETn RESETn__par VSS 4.11121e-14
Rpar_VDD VDD VDD__par 79.5773
Cpar_VDD VDD__par VSS 6.85875e-14
Rpar_VSS VSS VSS__par 65.6263
Cpar_VSS VSS__par VSS 1.11462e-13

* ---- non-MOS devices: IDEAL, verbatim from the schematic ----
* from por_output_chain
XCDG NDG VSS cap_mim_2f0_m3m4_noshield c_width=11u c_length=11u m=1
* from por_output_chain
XCTIM TIM VSS cap_mim_2f0_m3m4_noshield c_width=28u c_length=28u m=4

.ends por_output_chain
