* bias_core -- klt lvs reference netlist
* generated by layout/lvs_reference.py from design/netlist/bias_core.spice
* Do not edit: edit the schematic, re-run design/netlist.py, re-run this.
.SUBCKT bias_core BIAS_OK IBIAS VDD VREF VSS vsubs
M1 NBG NBG VSS vsubs nfet L=4U W=2U
M2 NA PG VDD NW1 pfet L=4U W=8U
M3 NBTOP PG VDD NW1 pfet L=4U W=8U
M4 VREF PG VDD NW1 pfet L=4U W=8U
M5 NBG PG VDD NW1 pfet L=4U W=2U
M6 PB PB VDD NW1 pfet L=4U W=2U
M7 IBIAS PB VDD NW1 pfet L=4U W=40U
M8 NT PB VDD NW1 pfet L=4U W=2U
M9 N1 NA NT NW1 pfet L=4U W=16U
M10 N2 NB NT NW1 pfet L=4U W=16U
M11 PG PB VDD NW1 pfet L=4U W=2U
M12 NKM PB VDD NW1 pfet L=4U W=1U
M13 TOK PB VDD NW1 pfet L=4U W=1U
M14 NOKO NA TOK NW1 pfet L=4U W=8U
M15 NOKL NBTOP TOK NW1 pfet L=4U W=8U
M16 NOKX PB VDD NW1 pfet L=4U W=1U
M17 BIAS_OK NOKX VDD NW1 pfet L=4U W=1U
M18 PB NBG VSS vsubs nfet L=4U W=2U
M19 N1 N1 VSS vsubs nfet L=8U W=4U
M20 N2 N1 VSS vsubs nfet L=8U W=4U
M21 PG N2 VSS vsubs nfet L=8U W=8U
M22 VDD VDD KS1 vsubs nfet L=8U W=1U
M23 KS1 KS1 KS2 vsubs nfet L=8U W=1U
M24 KS2 KS2 KS3 vsubs nfet L=8U W=1U
M25 KS3 KS3 KS4 vsubs nfet L=8U W=1U
M26 KS4 KS4 NKG vsubs nfet L=8U W=1U
M27 NKM NKM VSS vsubs nfet L=4U W=2U
M28 NKG NKM VSS vsubs nfet L=4U W=8U
M29 PG NKG VSS vsubs nfet L=4U W=1U
M30 NOKL NOKL VSS vsubs nfet L=4U W=2U
M31 NOKO NOKL VSS vsubs nfet L=4U W=2U
M32 NOKO NKG VSS vsubs nfet L=1U W=2U
M33 NOKX NOKO VSS vsubs nfet L=4U W=2U
M34 BIAS_OK NOKX VSS vsubs nfet L=0.5U W=4U
.ENDS bias_core
