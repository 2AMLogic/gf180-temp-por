* por-brownout root-cause control @ tt / 27.0 C / 3.3 V -- GENERATED by run_dip_rootcause.py, do not edit
* pdk=gf180mcuD@c6d73a35f524070e85faff4a6a9eef49553ebc2b  harness=0.1.0

.param vdd_nom=3.3
.param vdd_val=3.3
.param temp_c=27.0

.include "/Users/rwalters/.volare/gf180mcuD/libs.tech/ngspice/design.ngspice"
.lib "/Users/rwalters/.volare/gf180mcuD/libs.tech/ngspice/sm141064.ngspice" typical
.lib "/Users/rwalters/.volare/gf180mcuD/libs.tech/ngspice/sm141064.ngspice" res_typical
.lib "/Users/rwalters/.volare/gf180mcuD/libs.tech/ngspice/sm141064.ngspice" bjt_typical
.lib "/Users/rwalters/.volare/gf180mcuD/libs.tech/ngspice/sm141064.ngspice" diode_typical
.lib "/Users/rwalters/.volare/gf180mcuD/libs.tech/ngspice/sm141064.ngspice" moscap_typical
.lib "/Users/rwalters/.volare/gf180mcuD/libs.tech/ngspice/sm141064.ngspice" mimcap_typical

.temp 27.0
.options reltol=1e-4
.options abstol=1e-13
.options vntol=1e-8
.options method=gear

.param t_dip=15.0m
.param t_edge=0.001m
.param t_dwell=0.05m
.param ibias_a=2.5e-07

.include "../starved_chain.spice"
.include "../../../../design/netlist/por_output_chain.spice"

.control
set numdgt=8
set noaskquit
tran 20u 15.051m
let rst_r = v(resetn)/(v(vdd)+0.001)
meas tran rst_pre find v(resetn) at=14.9m
meas tran rst_min min v(resetn) from=15.0m to=15.051m
meas tran rst_r_min min rst_r from=15.0m to=15.051m
meas tran rst_end find v(resetn) at=15.051m
meas tran t_assert when rst_r=0.1 fall=1 td=15.0m
meas tran ndg_end find v(xdut.ndg) at=15.051m
meas tran pgdg_end find v(xdut.pgdg) at=15.051m
meas tran isink_pre find i(vforce) at=14.9m
meas tran isink_end find i(vforce) at=15.051m
.endc
.end
